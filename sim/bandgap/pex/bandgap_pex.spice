*********************************************************
*** NGSPICE file created by KLayout-PEX 0.8.1
*** -----------------------------------------------------
***     Extraction Engine: KPEX/2.5D
***     Technology: sky130a
***     Date: 2026-11-09 17:19:31
*********************************************************

.SUBCKT BANDGAP A AH B BH N1 NB PB S TAIL VDD VREF VSS net1 net2 sky130_gnd
X$1 S.P0.psdm VSS.P0.poly VDD.P0.psdm VDD.P0.nwell sky130_fd_pr__pfet_01v8 l=8
+ w=0.42 as=0.126 ad=0.126 ps=1.44 pd=1.44
X$2 N1.P0.psdm N1.P0.poly VDD.P1.psdm VDD.P1.nwell sky130_fd_pr__pfet_01v8_lvt
+ l=4 w=4 as=1.2 ad=1.2 ps=8.6 pd=8.6
X$3 PB.P0.psdm N1.P1.poly VDD.P2.psdm VDD.P2.nwell sky130_fd_pr__pfet_01v8_lvt
+ l=4 w=4 as=1.2 ad=1.2 ps=8.6 pd=8.6
X$4 AH.P0.psdm PB.P0.poly VDD.P3.psdm VDD.P3.nwell sky130_fd_pr__pfet_01v8_lvt
+ l=4 w=8 as=2.4 ad=2.4 ps=16.6 pd=16.6
X$5 NB.P0.psdm PB.P1.poly VDD.P4.psdm VDD.P4.nwell sky130_fd_pr__pfet_01v8_lvt
+ l=4 w=8 as=2.4 ad=2.4 ps=16.6 pd=16.6
X$6 VREF.P0.psdm PB.P2.poly VDD.P5.psdm VDD.P5.nwell
+ sky130_fd_pr__pfet_01v8_lvt l=4 w=8 as=2.4 ad=2.4 ps=16.6 pd=16.6
X$7 BH.P0.psdm PB.P3.poly VDD.P6.psdm VDD.P6.nwell sky130_fd_pr__pfet_01v8_lvt
+ l=4 w=8 as=2.4 ad=2.4 ps=16.6 pd=16.6
X$8 PB.P0.nsdm S.P0.poly VSS.P0.nsdm sky130_gnd sky130_fd_pr__nfet_01v8 l=1
+ w=0.42 as=0.126 ad=0.126 ps=1.44 pd=1.44
X$9 S.P0.nsdm VREF.P0.poly VSS.P1.nsdm sky130_gnd sky130_fd_pr__nfet_01v8 l=1
+ w=1 as=0.3 ad=0.3 ps=2.6 pd=2.6
X$10 TAIL.P0.nsdm NB.P0.poly VSS.P2.nsdm sky130_gnd sky130_fd_pr__nfet_01v8 l=4
+ w=8 as=2.4 ad=2.4 ps=16.6 pd=16.6
X$11 NB.P0.nsdm NB.P1.poly VSS.P3.nsdm sky130_gnd sky130_fd_pr__nfet_01v8 l=4
+ w=8 as=2.4 ad=2.4 ps=16.6 pd=16.6
X$12 N1.P0.nsdm BH.P0.poly TAIL.P1.nsdm sky130_gnd sky130_fd_pr__nfet_01v8_lvt
+ l=4 w=16 as=4.8 ad=4.8 ps=32.6 pd=32.6
X$13 PB.P1.nsdm AH.P0.poly TAIL.P2.nsdm sky130_gnd sky130_fd_pr__nfet_01v8_lvt
+ l=4 w=16 as=4.8 ad=4.8 ps=32.6 pd=32.6
X$14 net1.P0.poly B.P0.poly sky130_gnd sky130_fd_pr__res_xhigh_po_0p35 l=2
X$15 net2.P0.poly VREF.P1.poly sky130_gnd sky130_fd_pr__res_xhigh_po_0p35
+ l=17.77
X$16 B.P1.poly BH.P1.poly sky130_gnd sky130_fd_pr__res_xhigh_po_2p85 l=60
X$17 A.P0.poly AH.P1.poly sky130_gnd sky130_fd_pr__res_xhigh_po_2p85 l=60
X$19 VSS.P0.li1 VSS.P0.li1 net1.P0.li1 sky130_fd_pr__pnp_05v5_W3p40L3p40 m=1
+ mult=1
X$20 VSS.P2.li1 VSS.P2.li1 net1.P100.li1 sky130_fd_pr__pnp_05v5_W3p40L3p40 m=1
+ mult=1
X$21 VSS.P4.li1 VSS.P4.li1 net1.P174.li1 sky130_fd_pr__pnp_05v5_W3p40L3p40 m=1
+ mult=1
X$22 VSS.P6.li1 VSS.P6.li1 net1.P261.li1 sky130_fd_pr__pnp_05v5_W3p40L3p40 m=1
+ mult=1
X$23 VSS.P8.li1 VSS.P8.li1 net1.P348.li1 sky130_fd_pr__pnp_05v5_W3p40L3p40 m=1
+ mult=1
X$24 VSS.P10.li1 VSS.P10.li1 net1.P435.li1 sky130_fd_pr__pnp_05v5_W3p40L3p40
+ m=1 mult=1
X$25 VSS.P12.li1 VSS.P12.li1 net1.P522.li1 sky130_fd_pr__pnp_05v5_W3p40L3p40
+ m=1 mult=1
X$26 VSS.P14.li1 VSS.P14.li1 net1.P609.li1 sky130_fd_pr__pnp_05v5_W3p40L3p40
+ m=1 mult=1
X$27 VSS.P16.li1 VSS.P16.li1 net2.P0.li1 sky130_fd_pr__pnp_05v5_W3p40L3p40 m=1
+ mult=1
X$28 VSS.P18.li1 VSS.P18.li1 A.P0.li1 sky130_fd_pr__pnp_05v5_W3p40L3p40 m=1
+ mult=1
Cext_1 \$I102 net1.$579.met1 0.001879f
Cext_2 \$I102 net2 0.0437849f
Cext_3 \$I102 net2.$43.met1 0.00471709f
Cext_4 \$I102 net2.$44.met1 0.0225855f
Cext_5 \$I102 net2.$50.met1 0.00694938f
Cext_6 \$I102 net2.$56.met1 0.00694938f
Cext_7 \$I102 net2.$62.met1 0.00694938f
Cext_8 \$I102 net2.$68.met1 0.00694938f
Cext_9 \$I102 net2.$74.met1 0.0289789f
Cext_10 \$I102 net2.$87.met2 0.00344146f
Cext_11 \$I102 net2.P0.li1 0.536139f
Cext_12 \$I102 PB.$5947.met4 0.0122147f
Cext_13 \$I102 VDD.P0.met3 0.0123194f
Cext_14 \$I102 VSS.$110.li1 0.166439f
Cext_15 \$I102 VSS.$116.li1 0.130092f
Cext_16 \$I102 VSS.$298.met1 0.00692698f
Cext_17 \$I102 VSS.$305.met1 0.00362533f
Cext_18 \$I102 VSS.$397.met2 0.0055649f
Cext_19 \$I102 VSS.$398.met2 0.00241992f
Cext_20 \$I102 VSS.$402.met2 0.00937415f
Cext_21 \$I102 VSS.$423.met3 0.0335879f
Cext_22 \$I102 VSS.$425.met3 0.0253748f
Cext_23 \$I102 VSS.P16.li1 0.318022f
Cext_24 \$I103 VSS.$11.li1 0.00207093f
Cext_25 \$I103 VSS.$8.li1 0.00186092f
Cext_26 \$I103 VSS.P18.li1 0.00318526f
Cext_27 \$I106 A 0.0358962f
Cext_28 \$I106 A.$100.met1 0.00694938f
Cext_29 \$I106 A.$101.met1 0.00694938f
Cext_30 \$I106 A.$107.met1 0.00694938f
Cext_31 \$I106 A.$113.met1 0.00694938f
Cext_32 \$I106 A.$119.met1 0.0289789f
Cext_33 \$I106 A.$174.met2 0.00335911f
Cext_34 \$I106 A.$88.met1 0.0046936f
Cext_35 \$I106 A.$89.met1 0.0225855f
Cext_36 \$I106 A.P0.li1 0.535616f
Cext_37 \$I106 net1.$394.met1 0.00329901f
Cext_38 \$I106 net1.$489.met1 0.00327979f
Cext_39 \$I106 net1.$604.met2 0.0168214f
Cext_40 \$I106 net1.$606.met2 0.00783845f
Cext_41 \$I106 net1.$607.met2 0.00775414f
Cext_42 \$I106 net1.$617.met3 0.00535003f
Cext_43 \$I106 net1.$618.met3 0.0425405f
Cext_44 \$I106 net1.$619.met3 0.00871498f
Cext_45 \$I106 VSS.$11.li1 0.165901f
Cext_46 \$I106 VSS.$223.met1 0.00362533f
Cext_47 \$I106 VSS.$229.met1 0.00691052f
Cext_48 \$I106 VSS.$371.met2 0.012215f
Cext_49 \$I106 VSS.$374.met2 0.0328277f
Cext_50 \$I106 VSS.$8.li1 0.129288f
Cext_51 \$I106 VSS.P18.li1 0.318872f
Cext_52 \$I67 VSS.$0.li1 0.00202563f
Cext_53 \$I67 VSS.$2.li1 0.00121314f
Cext_54 \$I67 VSS.P0.li1 0.00387834f
Cext_55 \$I70 net1 0.0390554f
Cext_56 \$I70 net1.$295.met1 0.00557095f
Cext_57 \$I70 net1.$298.met1 0.0223708f
Cext_58 \$I70 net1.$316.met1 0.00694938f
Cext_59 \$I70 net1.$334.met1 0.00694938f
Cext_60 \$I70 net1.$352.met1 0.00694938f
Cext_61 \$I70 net1.$370.met1 0.00670958f
Cext_62 \$I70 net1.$388.met1 0.0286105f
Cext_63 \$I70 net1.$408.met1 0.00324135f
Cext_64 \$I70 net1.$598.met2 0.00429165f
Cext_65 \$I70 net1.$616.met3 0.0424969f
Cext_66 \$I70 net1.P0.li1 0.539576f
Cext_67 \$I70 VSS.$0.li1 0.150704f
Cext_68 \$I70 VSS.$2.li1 0.150579f
Cext_69 \$I70 VSS.$208.met1 0.00860545f
Cext_70 \$I70 VSS.$212.met1 0.00224319f
Cext_71 \$I70 VSS.$356.met2 0.00318929f
Cext_72 \$I70 VSS.$357.met2 0.00870915f
Cext_73 \$I70 VSS.$360.met2 0.00750354f
Cext_74 \$I70 VSS.$365.met2 0.00187647f
Cext_75 \$I70 VSS.$367.met2 0.0015059f
Cext_76 \$I70 VSS.$370.met2 0.00162997f
Cext_77 \$I70 VSS.$373.met2 0.00357841f
Cext_78 \$I70 VSS.$412.met3 0.0174704f
Cext_79 \$I70 VSS.$413.met3 0.0112567f
Cext_80 \$I70 VSS.P0.li1 0.311814f
Cext_81 \$I71 VSS.$58.li1 0.00186092f
Cext_82 \$I71 VSS.$59.li1 0.00207093f
Cext_83 \$I71 VSS.P2.li1 0.00318526f
Cext_84 \$I74 A 0.00111163f
Cext_85 \$I74 net1.$474.met1 0.00336306f
Cext_86 \$I74 net1.$482.met1 0.0046936f
Cext_87 \$I74 net1.$495.met1 0.0225855f
Cext_88 \$I74 net1.$513.met1 0.00694938f
Cext_89 \$I74 net1.$531.met1 0.00694938f
Cext_90 \$I74 net1.$549.met1 0.00694938f
Cext_91 \$I74 net1.$567.met1 0.00694938f
Cext_92 \$I74 net1.$585.met1 0.0289789f
Cext_93 \$I74 net1.$612.met2 0.0489762f
Cext_94 \$I74 net1.P100.li1 0.540592f
Cext_95 \$I74 net2 0.00449235f
Cext_96 \$I74 net2.$88.met2 0.00162992f
Cext_97 \$I74 VSS.$259.met1 0.00362533f
Cext_98 \$I74 VSS.$261.met1 0.00694448f
Cext_99 \$I74 VSS.$381.met2 0.0124653f
Cext_100 \$I74 VSS.$382.met2 0.0126646f
Cext_101 \$I74 VSS.$384.met2 0.00268693f
Cext_102 \$I74 VSS.$388.met2 0.0204678f
Cext_103 \$I74 VSS.$418.met3 0.0158595f
Cext_104 \$I74 VSS.$419.met3 0.006201f
Cext_105 \$I74 VSS.$420.met3 0.00701921f
Cext_106 \$I74 VSS.$58.li1 0.129597f
Cext_107 \$I74 VSS.$59.li1 0.165867f
Cext_108 \$I74 VSS.P2.li1 0.316852f
Cext_109 \$I75 VSS.$12.li1 0.0028485f
Cext_110 \$I75 VSS.$58.li1 0.00104744f
Cext_111 \$I75 VSS.$59.li1 0.00136025f
Cext_112 \$I75 VSS.$9.li1 0.00186092f
Cext_113 \$I78 A 0.0627282f
Cext_114 \$I78 net1.$400.met1 0.00342712f
Cext_115 \$I78 net1.$407.met1 0.0046936f
Cext_116 \$I78 net1.$414.met1 0.0225855f
Cext_117 \$I78 net1.$426.met1 0.00694938f
Cext_118 \$I78 net1.$438.met1 0.00694938f
Cext_119 \$I78 net1.$450.met1 0.00694938f
Cext_120 \$I78 net1.$462.met1 0.00694938f
Cext_121 \$I78 net1.$474.met1 0.0289441f
Cext_122 \$I78 net1.$495.met1 0.00336306f
Cext_123 \$I78 net1.$605.met2 0.0120545f
Cext_124 \$I78 net1.$612.met2 0.00342548f
Cext_125 \$I78 net1.$618.met3 0.00463922f
Cext_126 \$I78 net1.$619.met3 0.00124192f
Cext_127 \$I78 net1.P174.li1 0.535616f
Cext_128 \$I78 VSS.$12.li1 0.165835f
Cext_129 \$I78 VSS.$224.met1 0.00362533f
Cext_130 \$I78 VSS.$230.met1 0.00691052f
Cext_131 \$I78 VSS.$369.met2 0.0173034f
Cext_132 \$I78 VSS.$375.met2 0.0200869f
Cext_133 \$I78 VSS.$381.met2 0.00462335f
Cext_134 \$I78 VSS.$382.met2 0.00694442f
Cext_135 \$I78 VSS.$416.met3 0.0315091f
Cext_136 \$I78 VSS.$418.met3 0.00104996f
Cext_137 \$I78 VSS.$419.met3 0.0176285f
Cext_138 \$I78 VSS.$58.li1 0.0173848f
Cext_139 \$I78 VSS.$59.li1 0.0174998f
Cext_140 \$I78 VSS.$9.li1 0.129597f
Cext_141 \$I78 VSS.P4.li1 0.282878f
Cext_142 \$I79 VSS.$1.li1 0.00294961f
Cext_143 \$I79 VSS.$12.li1 0.00111204f
Cext_144 \$I79 VSS.$3.li1 0.00107218f
Cext_145 \$I79 VSS.$4.li1 0.00198328f
Cext_146 \$I82 net1.$297.met1 0.00471709f
Cext_147 \$I82 net1.$310.met1 0.0225855f
Cext_148 \$I82 net1.$328.met1 0.00694938f
Cext_149 \$I82 net1.$346.met1 0.00694938f
Cext_150 \$I82 net1.$364.met1 0.00694938f
Cext_151 \$I82 net1.$382.met1 0.00654885f
Cext_152 \$I82 net1.$400.met1 0.0289441f
Cext_153 \$I82 net1.$414.met1 0.00340791f
Cext_154 \$I82 net1.$601.met2 0.0180412f
Cext_155 \$I82 net1.P261.li1 0.538865f
Cext_156 \$I82 VSS.$1.li1 0.179245f
Cext_157 \$I82 VSS.$12.li1 0.0109449f
Cext_158 \$I82 VSS.$209.met1 0.00697006f
Cext_159 \$I82 VSS.$214.met1 0.00224319f
Cext_160 \$I82 VSS.$3.li1 0.0191901f
Cext_161 \$I82 VSS.$358.met2 0.029403f
Cext_162 \$I82 VSS.$359.met2 0.0477041f
Cext_163 \$I82 VSS.$361.met2 0.0275598f
Cext_164 \$I82 VSS.$363.met2 0.0038477f
Cext_165 \$I82 VSS.$369.met2 0.00569812f
Cext_166 \$I82 VSS.$375.met2 0.00831635f
Cext_167 \$I82 VSS.$4.li1 0.219274f
Cext_168 \$I82 VSS.$414.met3 0.0275652f
Cext_169 \$I82 VSS.P6.li1 0.184837f
Cext_170 \$I83 VSS.$61.li1 0.00207093f
Cext_171 \$I83 VSS.$64.li1 0.00186092f
Cext_172 \$I83 VSS.P8.li1 0.00318526f
Cext_173 \$I86 A 0.00260278f
Cext_174 \$I86 A.$119.met1 0.00369617f
Cext_175 \$I86 net1.$481.met1 0.0046936f
Cext_176 \$I86 net1.$489.met1 0.0225855f
Cext_177 \$I86 net1.$507.met1 0.00694938f
Cext_178 \$I86 net1.$525.met1 0.00694938f
Cext_179 \$I86 net1.$543.met1 0.00694938f
Cext_180 \$I86 net1.$561.met1 0.00694938f
Cext_181 \$I86 net1.$579.met1 0.0289789f
Cext_182 \$I86 net1.$606.met2 0.0301129f
Cext_183 \$I86 net1.$607.met2 0.0246247f
Cext_184 \$I86 net1.$611.met2 0.00512175f
Cext_185 \$I86 net1.$619.met3 0.00761297f
Cext_186 \$I86 net1.P348.li1 0.543685f
Cext_187 \$I86 net2 0.00455867f
Cext_188 \$I86 net2.$44.met1 0.0017487f
Cext_189 \$I86 VSS.$264.met1 0.00694448f
Cext_190 \$I86 VSS.$271.met1 0.00362533f
Cext_191 \$I86 VSS.$386.met2 0.00517391f
Cext_192 \$I86 VSS.$387.met2 0.0511409f
Cext_193 \$I86 VSS.$388.met2 0.00689896f
Cext_194 \$I86 VSS.$391.met2 0.0236092f
Cext_195 \$I86 VSS.$418.met3 0.00541183f
Cext_196 \$I86 VSS.$420.met3 0.00105001f
Cext_197 \$I86 VSS.$421.met3 0.00723086f
Cext_198 \$I86 VSS.$61.li1 0.166055f
Cext_199 \$I86 VSS.$64.li1 0.129518f
Cext_200 \$I86 VSS.P8.li1 0.317691f
Cext_201 \$I87 VSS.$3.li1 0.00180342f
Cext_202 \$I87 VSS.$5.li1 0.00401918f
Cext_203 \$I87 VSS.P10.li1 0.00129451f
Cext_204 \$I90 A.$89.met1 0.00336306f
Cext_205 \$I90 net1.$296.met1 0.00550128f
Cext_206 \$I90 net1.$304.met1 0.0225855f
Cext_207 \$I90 net1.$322.met1 0.00694938f
Cext_208 \$I90 net1.$340.met1 0.00694938f
Cext_209 \$I90 net1.$358.met1 0.00694938f
Cext_210 \$I90 net1.$376.met1 0.00654885f
Cext_211 \$I90 net1.$394.met1 0.0284741f
Cext_212 \$I90 net1.$600.met2 0.0538372f
Cext_213 \$I90 net1.$616.met3 0.00134808f
Cext_214 \$I90 net1.P435.li1 0.542416f
Cext_215 \$I90 VSS.$0.li1 0.00572323f
Cext_216 \$I90 VSS.$213.met1 0.00224319f
Cext_217 \$I90 VSS.$218.met1 0.00842437f
Cext_218 \$I90 VSS.$3.li1 0.217557f
Cext_219 \$I90 VSS.$356.met2 0.00242976f
Cext_220 \$I90 VSS.$358.met2 0.00325824f
Cext_221 \$I90 VSS.$359.met2 0.00177042f
Cext_222 \$I90 VSS.$363.met2 0.0316281f
Cext_223 \$I90 VSS.$365.met2 0.00229004f
Cext_224 \$I90 VSS.$367.met2 0.0331606f
Cext_225 \$I90 VSS.$371.met2 0.00331266f
Cext_226 \$I90 VSS.$374.met2 0.005687f
Cext_227 \$I90 VSS.$412.met3 0.0105147f
Cext_228 \$I90 VSS.$413.met3 0.0057505f
Cext_229 \$I90 VSS.$5.li1 0.17028f
Cext_230 \$I90 VSS.P10.li1 0.220705f
Cext_231 \$I91 VSS.$60.li1 0.00377358f
Cext_232 \$I91 VSS.$61.li1 0.00136025f
Cext_233 \$I91 VSS.$63.li1 0.00198328f
Cext_234 \$I94 net1.$468.met1 0.00376023f
Cext_235 \$I94 net1.$480.met1 0.00471709f
Cext_236 \$I94 net1.$483.met1 0.0225507f
Cext_237 \$I94 net1.$501.met1 0.00694938f
Cext_238 \$I94 net1.$519.met1 0.00694938f
Cext_239 \$I94 net1.$537.met1 0.00694938f
Cext_240 \$I94 net1.$555.met1 0.00694938f
Cext_241 \$I94 net1.$573.met1 0.0288885f
Cext_242 \$I94 net1.$607.met2 0.00203388f
Cext_243 \$I94 net1.$608.met2 0.0288343f
Cext_244 \$I94 net1.$609.met2 0.0178741f
Cext_245 \$I94 net1.$620.met3 0.0180879f
Cext_246 \$I94 net1.P522.li1 0.540107f
Cext_247 \$I94 VSS.$263.met1 0.00697006f
Cext_248 \$I94 VSS.$270.met1 0.00224319f
Cext_249 \$I94 VSS.$385.met2 0.0407391f
Cext_250 \$I94 VSS.$386.met2 0.00132283f
Cext_251 \$I94 VSS.$387.met2 0.0130372f
Cext_252 \$I94 VSS.$391.met2 0.00596267f
Cext_253 \$I94 VSS.$394.met2 0.0412422f
Cext_254 \$I94 VSS.$421.met3 0.00191047f
Cext_255 \$I94 VSS.$60.li1 0.179584f
Cext_256 \$I94 VSS.$61.li1 0.0174249f
Cext_257 \$I94 VSS.$63.li1 0.218892f
Cext_258 \$I94 VSS.P12.li1 0.19727f
Cext_259 \$I95 VSS.$10.li1 0.00119578f
Cext_260 \$I95 VSS.$7.li1 0.0014484f
Cext_261 \$I95 VSS.P14.li1 0.00447293f
Cext_262 \$I98 A 0.00556483f
Cext_263 \$I98 net1 0.00203433f
Cext_264 \$I98 net1.$388.met1 0.00363852f
Cext_265 \$I98 net1.$406.met1 0.00550128f
Cext_266 \$I98 net1.$408.met1 0.0223708f
Cext_267 \$I98 net1.$420.met1 0.00694938f
Cext_268 \$I98 net1.$432.met1 0.00694938f
Cext_269 \$I98 net1.$444.met1 0.00694938f
Cext_270 \$I98 net1.$456.met1 0.00694938f
Cext_271 \$I98 net1.$468.met1 0.0289789f
Cext_272 \$I98 net1.$483.met1 0.00336306f
Cext_273 \$I98 net1.$602.met2 0.0040392f
Cext_274 \$I98 net1.$603.met2 0.00163169f
Cext_275 \$I98 net1.$608.met2 0.0126597f
Cext_276 \$I98 net1.$609.met2 0.00163597f
Cext_277 \$I98 net1.$617.met3 0.0630523f
Cext_278 \$I98 net1.$618.met3 0.00717846f
Cext_279 \$I98 net1.$619.met3 0.00170797f
Cext_280 \$I98 net1.P609.li1 0.536219f
Cext_281 \$I98 VSS.$10.li1 0.123828f
Cext_282 \$I98 VSS.$222.met1 0.00205896f
Cext_283 \$I98 VSS.$228.met1 0.00838696f
Cext_284 \$I98 VSS.$370.met2 0.00761152f
Cext_285 \$I98 VSS.$373.met2 0.0167058f
Cext_286 \$I98 VSS.$385.met2 0.00302756f
Cext_287 \$I98 VSS.$413.met3 0.00144434f
Cext_288 \$I98 VSS.$7.li1 0.0477963f
Cext_289 \$I98 VSS.P14.li1 0.440651f
Cext_290 \$I99 VSS.$110.li1 0.00207093f
Cext_291 \$I99 VSS.$116.li1 0.00186092f
Cext_292 \$I99 VSS.P16.li1 0.00318526f
Cext_293 A net1.$414.met1 0.142219f
Cext_294 A net1.$426.met1 0.0242836f
Cext_295 A net1.$438.met1 0.175389f
Cext_296 A net1.$462.met1 0.183179f
Cext_297 A net1.$604.met2 0.113563f
Cext_298 A net1.$605.met2 0.103183f
Cext_299 A net1.$606.met2 0.0157256f
Cext_300 A net1.$607.met2 0.00280244f
Cext_301 A net1.$611.met2 0.00109902f
Cext_302 A net1.$612.met2 0.0120877f
Cext_303 A net1.$618.met3 0.090646f
Cext_304 A net1.$619.met3 0.0174063f
Cext_305 A net1.P174.li1 0.0443268f
Cext_306 A VSS.$11.li1 0.0127201f
Cext_307 A VSS.$12.li1 0.0372321f
Cext_308 A VSS.$369.met2 0.0272941f
Cext_309 A VSS.$372.met2 0.00399687f
Cext_310 A VSS.$374.met2 0.00789474f
Cext_311 A VSS.$375.met2 0.0235708f
Cext_312 A VSS.$381.met2 0.00940678f
Cext_313 A VSS.$382.met2 0.00890408f
Cext_314 A VSS.$383.met2 0.0036937f
Cext_315 A VSS.$416.met3 0.062095f
Cext_316 A VSS.$419.met3 0.0174063f
Cext_317 A VSS.$58.li1 0.00463188f
Cext_318 A VSS.$59.li1 0.00960648f
Cext_319 A VSS.$61.li1 0.00117962f
Cext_320 A VSS.$7.li1 0.0014917f
Cext_321 A VSS.$8.li1 0.03441f
Cext_322 A VSS.$9.li1 0.0436915f
Cext_323 A VSS.P18.li1 0.0507534f
Cext_324 A VSS.P4.li1 0.0842727f
Cext_325 A VSS.P8.li1 0.00340509f
Cext_326 A sky130_gnd 0.212118f
Cext_327 A.$100.met1 net1.$420.met1 0.00211538f
Cext_328 A.$100.met1 net1.$426.met1 0.00211538f
Cext_329 A.$100.met1 net1.$604.met2 0.0925584f
Cext_330 A.$100.met1 net1.$618.met3 0.0332988f
Cext_331 A.$100.met1 VSS.$11.li1 0.00657773f
Cext_332 A.$100.met1 VSS.$8.li1 0.00709044f
Cext_333 A.$100.met1 sky130_gnd 0.0116842f
Cext_334 A.$101.met1 net1.$432.met1 0.00211538f
Cext_335 A.$101.met1 net1.$438.met1 0.00211538f
Cext_336 A.$101.met1 net1.$618.met3 0.00827713f
Cext_337 A.$101.met1 VSS.$11.li1 0.00456269f
Cext_338 A.$101.met1 VSS.$8.li1 0.00566578f
Cext_339 A.$101.met1 VSS.P18.li1 0.00338842f
Cext_340 A.$101.met1 sky130_gnd 0.0115797f
Cext_341 A.$107.met1 net1.$444.met1 0.00211538f
Cext_342 A.$107.met1 net1.$450.met1 0.00211538f
Cext_343 A.$107.met1 net1.$618.met3 0.0383928f
Cext_344 A.$107.met1 VSS.$8.li1 0.00190471f
Cext_345 A.$107.met1 VSS.P18.li1 0.0109044f
Cext_346 A.$107.met1 sky130_gnd 0.0116842f
Cext_347 A.$113.met1 net1.$456.met1 0.00211538f
Cext_348 A.$113.met1 net1.$462.met1 0.00211538f
Cext_349 A.$113.met1 net1.$606.met2 0.00225316f
Cext_350 A.$113.met1 net1.$618.met3 0.0371824f
Cext_351 A.$113.met1 VSS.P18.li1 0.0127021f
Cext_352 A.$113.met1 sky130_gnd 0.0116842f
Cext_353 A.$119.met1 net1.$468.met1 0.00236923f
Cext_354 A.$119.met1 net1.$474.met1 0.00236923f
Cext_355 A.$119.met1 net1.$481.met1 0.00168027f
Cext_356 A.$119.met1 net1.$489.met1 0.0112538f
Cext_357 A.$119.met1 net1.$618.met3 0.0439256f
Cext_358 A.$119.met1 net1.$619.met3 0.00996039f
Cext_359 A.$119.met1 VSS.$61.li1 0.00145756f
Cext_360 A.$119.met1 VSS.P18.li1 0.0553043f
Cext_361 A.$119.met1 VSS.P8.li1 0.00150077f
Cext_362 A.$119.met1 sky130_gnd 0.0484286f
Cext_363 A.$125.met1 B.$107.met1 0.0151681f
Cext_364 A.$125.met1 sky130_gnd 0.0777533f
Cext_365 A.$126.met1 VREF.$106.met2 0.00116426f
Cext_366 A.$126.met1 sky130_gnd 0.028901f
Cext_367 A.$127.met1 VREF.$105.met2 0.00135634f
Cext_368 A.$127.met1 sky130_gnd 0.028901f
Cext_369 A.$128.met1 B.$119.met3 0.00474797f
Cext_370 A.$128.met1 VREF.$105.met2 0.00135634f
Cext_371 A.$128.met1 VREF.$110.met3 0.0133072f
Cext_372 A.$128.met1 sky130_gnd 0.028901f
Cext_373 A.$129.met1 VREF.$105.met2 0.00513445f
Cext_374 A.$129.met1 VREF.$110.met3 0.00297004f
Cext_375 A.$129.met1 sky130_gnd 0.028901f
Cext_376 A.$130.met1 VREF.$105.met2 0.00135634f
Cext_377 A.$130.met1 sky130_gnd 0.028901f
Cext_378 A.$131.met1 VREF.$105.met2 0.00135634f
Cext_379 A.$131.met1 sky130_gnd 0.028901f
Cext_380 A.$132.met1 VREF.$105.met2 0.00111144f
Cext_381 A.$132.met1 VREF.$110.met3 0.00193961f
Cext_382 A.$132.met1 sky130_gnd 0.107435f
Cext_383 A.$141.met1 B.$107.met1 0.00172897f
Cext_384 A.$141.met1 sky130_gnd 0.00577498f
Cext_385 A.$174.met2 net1.$603.met2 0.00134921f
Cext_386 A.$174.met2 net1.$618.met3 0.0033368f
Cext_387 A.$174.met2 VSS.$11.li1 0.00591257f
Cext_388 A.$174.met2 VSS.$374.met2 0.0137073f
Cext_389 A.$174.met2 sky130_gnd 0.0046675f
Cext_390 A.$175.met2 net1.$438.met1 0.0185533f
Cext_391 A.$175.met2 VSS.$380.met2 0.00515941f
Cext_392 A.$175.met2 VSS.$383.met2 0.0508869f
Cext_393 A.$175.met2 VSS.$416.met3 0.0279403f
Cext_394 A.$175.met2 VSS.$9.li1 0.00869625f
Cext_395 A.$175.met2 sky130_gnd 1.05361f
Cext_396 A.$176.met2 B.$102.met1 0.0178426f
Cext_397 A.$176.met2 B.$103.met1 0.0340518f
Cext_398 A.$176.met2 B.$104.met1 0.0562024f
Cext_399 A.$176.met2 B.$105.met1 0.0544828f
Cext_400 A.$176.met2 B.$106.met1 0.0544828f
Cext_401 A.$176.met2 B.$107.met1 0.0448028f
Cext_402 A.$176.met2 B.$11.li1 0.00289214f
Cext_403 A.$176.met2 B.$115.met2 0.00576389f
Cext_404 A.$176.met2 B.$116.met2 0.00534722f
Cext_405 A.$176.met2 VDD.$497.met2 0.00696449f
Cext_406 A.$176.met2 VREF.$106.met2 0.0140979f
Cext_407 A.$176.met2 sky130_gnd 0.116701f
Cext_408 A.$177.met2 B.$107.met1 0.0180305f
Cext_409 A.$177.met2 B.$11.li1 0.00657475f
Cext_410 A.$177.met2 B.$124.poly 0.00292379f
Cext_411 A.$177.met2 VDD.$497.met2 0.00695956f
Cext_412 A.$177.met2 VREF.$106.met2 0.0172685f
Cext_413 A.$177.met2 sky130_gnd 0.156213f
Cext_414 A.$178.met3 net1.$621.met3 0.242105f
Cext_415 A.$178.met3 net2.$88.met2 0.000233777f
Cext_416 A.$178.met3 PB.$5927.met2 0.0644953f
Cext_417 A.$178.met3 PB.$5928.met2 0.0279403f
Cext_418 A.$178.met3 VSS.$380.met2 0.0831774f
Cext_419 A.$178.met3 VSS.$383.met2 0.0279403f
Cext_420 A.$178.met3 sky130_gnd 1.87512f
Cext_421 A.$179.met3 B.$101.met1 0.0128223f
Cext_422 A.$179.met3 B.$102.met1 0.00654851f
Cext_423 A.$179.met3 B.$103.met1 0.0202218f
Cext_424 A.$179.met3 B.$104.met1 0.0159122f
Cext_425 A.$179.met3 B.$106.met1 0.0158638f
Cext_426 A.$179.met3 B.$119.met3 0.0234234f
Cext_427 A.$179.met3 B.$122.poly 0.00117558f
Cext_428 A.$179.met3 B.$15.li1 0.00364273f
Cext_429 A.$179.met3 B.$16.li1 0.00286602f
Cext_430 A.$179.met3 B.P1.poly 0.00156846f
Cext_431 A.$179.met3 net1.$621.met3 0.222638f
Cext_432 A.$179.met3 PB.$5927.met2 0.0267271f
Cext_433 A.$179.met3 VDD.$497.met2 0.107582f
Cext_434 A.$179.met3 VDD.$508.met3 0.128283f
Cext_435 A.$179.met3 VDD.$510.met3 0.0236118f
Cext_436 A.$179.met3 sky130_gnd 1.67606f
Cext_437 A.$180.poly B.$124.poly 0.007f
Cext_438 A.$180.poly sky130_gnd 0.344094f
Cext_439 A.$181.poly sky130_gnd 0.17712f
Cext_440 A.$182.poly sky130_gnd 0.17712f
Cext_441 A.$183.poly VREF.$110.met3 0.00101953f
Cext_442 A.$183.poly sky130_gnd 0.354459f
Cext_443 A.$40.li1 B.$11.li1 0.0108425f
Cext_444 A.$40.li1 sky130_gnd 0.0951158f
Cext_445 A.$41.li1 sky130_gnd 0.0301038f
Cext_446 A.$42.li1 sky130_gnd 0.0301038f
Cext_447 A.$43.li1 sky130_gnd 0.0301038f
Cext_448 A.$44.li1 sky130_gnd 0.0301038f
Cext_449 A.$45.li1 sky130_gnd 0.0301038f
Cext_450 A.$46.li1 sky130_gnd 0.0301038f
Cext_451 A.$47.li1 VREF.$110.met3 0.00281357f
Cext_452 A.$47.li1 sky130_gnd 0.116764f
Cext_453 A.$88.met1 net1.$408.met1 0.00169414f
Cext_454 A.$88.met1 VSS.$11.li1 0.00738981f
Cext_455 A.$88.met1 VSS.$229.met1 0.00837925f
Cext_456 A.$88.met1 sky130_gnd 0.00526484f
Cext_457 A.$89.met1 net1.$394.met1 0.0115712f
Cext_458 A.$89.met1 net1.$407.met1 0.00168027f
Cext_459 A.$89.met1 net1.$604.met2 0.126089f
Cext_460 A.$89.met1 net1.$605.met2 0.0177299f
Cext_461 A.$89.met1 net1.$618.met3 0.0136462f
Cext_462 A.$89.met1 VSS.$11.li1 0.0274608f
Cext_463 A.$89.met1 VSS.$371.met2 0.00480172f
Cext_464 A.$89.met1 VSS.$374.met2 0.0200578f
Cext_465 A.$89.met1 VSS.$5.li1 0.00129941f
Cext_466 A.$89.met1 VSS.$8.li1 0.0170088f
Cext_467 A.$89.met1 sky130_gnd 0.0377668f
Cext_468 A.P0.li1 net1.$604.met2 0.0200926f
Cext_469 A.P0.li1 net1.$606.met2 0.00152415f
Cext_470 A.P0.li1 net1.$607.met2 0.00115681f
Cext_471 A.P0.li1 net1.$618.met3 0.028432f
Cext_472 A.P0.li1 VSS.$11.li1 0.109563f
Cext_473 A.P0.li1 VSS.$229.met1 0.00230162f
Cext_474 A.P0.li1 VSS.$371.met2 0.00403879f
Cext_475 A.P0.li1 VSS.$374.met2 0.0140471f
Cext_476 A.P0.li1 VSS.$8.li1 0.0674796f
Cext_477 A.P0.li1 VSS.P18.li1 0.218049f
Cext_478 A.P0.poly sky130_gnd 0.119207f
Cext_479 AH BH.$236.met2 0.0452615f
Cext_480 AH BH.$241.met3 0.0600492f
Cext_481 AH BH.$242.met3 0.0684913f
Cext_482 AH BH.$248.poly 0.0491954f
Cext_483 AH BH.P0.poly 0.0169598f
Cext_484 AH N1.P0.nsdm 0.0109937f
Cext_485 AH PB.$11468.poly 0.00694878f
Cext_486 AH PB.$11490.poly 0.0140664f
Cext_487 AH PB.$5798.met1 0.00324614f
Cext_488 AH TAIL.$148.li1 0.001468f
Cext_489 AH TAIL.$150.li1 0.001468f
Cext_490 AH TAIL.$152.li1 0.001468f
Cext_491 AH TAIL.$154.li1 0.001468f
Cext_492 AH TAIL.$156.li1 0.001468f
Cext_493 AH TAIL.$158.li1 0.001468f
Cext_494 AH TAIL.$160.li1 0.001468f
Cext_495 AH TAIL.$162.li1 0.001468f
Cext_496 AH TAIL.$164.li1 0.001468f
Cext_497 AH TAIL.$166.li1 0.001468f
Cext_498 AH TAIL.$168.li1 0.001468f
Cext_499 AH TAIL.$170.li1 0.001468f
Cext_500 AH TAIL.$172.li1 0.001468f
Cext_501 AH TAIL.$174.li1 0.00132527f
Cext_502 AH TAIL.$294.met1 0.00332113f
Cext_503 AH TAIL.$295.met1 0.0100275f
Cext_504 AH TAIL.$296.met1 0.0100275f
Cext_505 AH TAIL.$297.met1 0.0100275f
Cext_506 AH TAIL.$298.met1 0.0100275f
Cext_507 AH TAIL.$299.met1 0.0100275f
Cext_508 AH TAIL.$300.met1 0.0100275f
Cext_509 AH TAIL.$301.met1 0.0100275f
Cext_510 AH TAIL.$302.met1 0.0100275f
Cext_511 AH TAIL.$303.met1 0.0100275f
Cext_512 AH TAIL.$304.met1 0.0100275f
Cext_513 AH TAIL.$305.met1 0.0100275f
Cext_514 AH TAIL.$306.met1 0.0100275f
Cext_515 AH TAIL.$307.met1 0.0100275f
Cext_516 AH TAIL.$308.met1 0.0090526f
Cext_517 AH TAIL.P2.nsdm 0.00484093f
Cext_518 AH VDD.$369.met1 0.00454119f
Cext_519 AH VDD.$44.li1 0.00771775f
Cext_520 AH VDD.$45.li1 0.0026622f
Cext_521 AH VDD.$478.met2 0.0123243f
Cext_522 AH VDD.$480.met2 0.0121426f
Cext_523 AH VDD.$49.li1 0.00322774f
Cext_524 AH VDD.$501.met3 0.0251994f
Cext_525 AH VDD.$55.li1 0.0120875f
Cext_526 AH VDD.$662.nwell 0.02051f
Cext_527 AH VDD.$667.nwell 0.00807718f
Cext_528 AH VDD.$679.nwell 0.00143538f
Cext_529 AH VDD.$68.li1 0.00321882f
Cext_530 AH VDD.$684.nwell 0.00938828f
Cext_531 AH VSS.$13.li1 0.00490808f
Cext_532 AH VSS.$220.met1 0.0135506f
Cext_533 AH VSS.$415.met3 0.0279403f
Cext_534 AH VSS.$6.li1 0.0150812f
Cext_535 AH sky130_gnd 0.635458f
Cext_536 AH.$10.li1 BH.$235.met2 0.00189195f
Cext_537 AH.$10.li1 sky130_gnd 0.0301038f
Cext_538 AH.$100.li1 sky130_gnd 0.0140353f
Cext_539 AH.$102.li1 sky130_gnd 0.0124499f
Cext_540 AH.$104.li1 sky130_gnd 0.0140353f
Cext_541 AH.$106.li1 sky130_gnd 0.0124499f
Cext_542 AH.$108.li1 sky130_gnd 0.0140353f
Cext_543 AH.$11.li1 BH.$235.met2 0.00379693f
Cext_544 AH.$11.li1 BH.$24.li1 0.00103612f
Cext_545 AH.$11.li1 BH.$36.li1 0.00103612f
Cext_546 AH.$11.li1 BH.$48.li1 0.00103612f
Cext_547 AH.$11.li1 BH.$60.li1 0.00103612f
Cext_548 AH.$11.li1 sky130_gnd 0.108f
Cext_549 AH.$110.li1 sky130_gnd 0.0124499f
Cext_550 AH.$112.li1 sky130_gnd 0.0140353f
Cext_551 AH.$114.li1 sky130_gnd 0.0124499f
Cext_552 AH.$116.li1 sky130_gnd 0.0140353f
Cext_553 AH.$118.li1 sky130_gnd 0.0124499f
Cext_554 AH.$12.li1 BH.$11.li1 0.0108425f
Cext_555 AH.$12.li1 BH.$237.met2 0.00852996f
Cext_556 AH.$12.li1 sky130_gnd 0.0951158f
Cext_557 AH.$120.li1 sky130_gnd 0.0140353f
Cext_558 AH.$122.li1 sky130_gnd 0.0124499f
Cext_559 AH.$124.li1 sky130_gnd 0.0140353f
Cext_560 AH.$126.li1 sky130_gnd 0.0124499f
Cext_561 AH.$128.li1 sky130_gnd 0.0140353f
Cext_562 AH.$13.li1 BH.$237.met2 0.00189195f
Cext_563 AH.$13.li1 sky130_gnd 0.0301038f
Cext_564 AH.$130.li1 sky130_gnd 0.0124499f
Cext_565 AH.$132.li1 sky130_gnd 0.0140353f
Cext_566 AH.$134.li1 sky130_gnd 0.0124499f
Cext_567 AH.$136.li1 sky130_gnd 0.0191686f
Cext_568 AH.$138.li1 sky130_gnd 0.0187227f
Cext_569 AH.$14.li1 BH.$237.met2 0.00189195f
Cext_570 AH.$14.li1 sky130_gnd 0.0301038f
Cext_571 AH.$140.met1 BH.$147.met1 0.0153177f
Cext_572 AH.$140.met1 BH.$237.met2 0.0246958f
Cext_573 AH.$140.met1 sky130_gnd 0.0777526f
Cext_574 AH.$141.met1 BH.$237.met2 0.0236119f
Cext_575 AH.$141.met1 sky130_gnd 0.028901f
Cext_576 AH.$142.met1 BH.$237.met2 0.0236153f
Cext_577 AH.$142.met1 sky130_gnd 0.028901f
Cext_578 AH.$143.met1 BH.$235.met2 0.0179925f
Cext_579 AH.$143.met1 BH.$237.met2 0.0148733f
Cext_580 AH.$143.met1 TAIL.$339.met3 0.0060434f
Cext_581 AH.$143.met1 sky130_gnd 0.028901f
Cext_582 AH.$144.met1 BH.$235.met2 0.0236153f
Cext_583 AH.$144.met1 sky130_gnd 0.028901f
Cext_584 AH.$145.met1 BH.$235.met2 0.0236153f
Cext_585 AH.$145.met1 sky130_gnd 0.028901f
Cext_586 AH.$146.met1 BH.$235.met2 0.0236153f
Cext_587 AH.$146.met1 sky130_gnd 0.028901f
Cext_588 AH.$147.met1 BH.$148.met1 0.00148304f
Cext_589 AH.$147.met1 BH.$161.met1 0.00191876f
Cext_590 AH.$147.met1 BH.$170.met1 0.00167802f
Cext_591 AH.$147.met1 BH.$180.met1 0.00173684f
Cext_592 AH.$147.met1 BH.$190.met1 0.00173684f
Cext_593 AH.$147.met1 BH.$235.met2 0.0197856f
Cext_594 AH.$147.met1 sky130_gnd 0.0954974f
Cext_595 AH.$15.li1 BH.$235.met2 0.00144105f
Cext_596 AH.$15.li1 BH.$237.met2 0.00119464f
Cext_597 AH.$15.li1 sky130_gnd 0.0301038f
Cext_598 AH.$156.met1 BH.$147.met1 0.00172897f
Cext_599 AH.$156.met1 BH.$237.met2 0.00251589f
Cext_600 AH.$156.met1 sky130_gnd 0.00577498f
Cext_601 AH.$16.li1 BH.$235.met2 0.00189195f
Cext_602 AH.$16.li1 sky130_gnd 0.0301038f
Cext_603 AH.$17.li1 BH.$235.met2 0.00189195f
Cext_604 AH.$17.li1 sky130_gnd 0.0301038f
Cext_605 AH.$189.met1 BH.$241.met3 0.00698402f
Cext_606 AH.$189.met1 PB.$11468.poly 0.0135496f
Cext_607 AH.$189.met1 VDD.$345.met1 0.00165509f
Cext_608 AH.$189.met1 VDD.$662.nwell 0.00291408f
Cext_609 AH.$189.met1 sky130_gnd 0.00688355f
Cext_610 AH.$190.met1 BH.$241.met3 0.00361512f
Cext_611 AH.$190.met1 PB.$11468.poly 0.0150493f
Cext_612 AH.$190.met1 VDD.$346.met1 0.00183333f
Cext_613 AH.$190.met1 VDD.$371.met1 0.00206943f
Cext_614 AH.$190.met1 VDD.$45.li1 0.00540441f
Cext_615 AH.$190.met1 VDD.$663.nwell 0.00168486f
Cext_616 AH.$190.met1 sky130_gnd 0.00563761f
Cext_617 AH.$191.met1 BH.$241.met3 0.00327377f
Cext_618 AH.$191.met1 PB.$11468.poly 0.0150995f
Cext_619 AH.$191.met1 VDD.$347.met1 0.00183333f
Cext_620 AH.$191.met1 VDD.$372.met1 0.00238554f
Cext_621 AH.$191.met1 VDD.$46.li1 0.00643675f
Cext_622 AH.$191.met1 VDD.$501.met3 0.00484428f
Cext_623 AH.$191.met1 VDD.$664.nwell 0.00204366f
Cext_624 AH.$191.met1 sky130_gnd 0.00649879f
Cext_625 AH.$192.met1 PB.$11468.poly 0.0151301f
Cext_626 AH.$192.met1 VDD.$348.met1 0.00183333f
Cext_627 AH.$192.met1 VDD.$373.met1 0.00238554f
Cext_628 AH.$192.met1 VDD.$47.li1 0.00639308f
Cext_629 AH.$192.met1 VDD.$500.met3 0.0102681f
Cext_630 AH.$192.met1 VDD.$501.met3 0.0106781f
Cext_631 AH.$192.met1 VDD.$665.nwell 0.00292992f
Cext_632 AH.$192.met1 sky130_gnd 0.00649879f
Cext_633 AH.$193.met1 PB.$11468.poly 0.0141676f
Cext_634 AH.$193.met1 VDD.$349.met1 0.00183333f
Cext_635 AH.$193.met1 VDD.$374.met1 0.00238554f
Cext_636 AH.$193.met1 VDD.$48.li1 0.00656696f
Cext_637 AH.$193.met1 VDD.$501.met3 0.001636f
Cext_638 AH.$193.met1 VDD.$666.nwell 0.00204366f
Cext_639 AH.$193.met1 sky130_gnd 0.00649879f
Cext_640 AH.$194.met1 PB.P0.poly 0.0149101f
Cext_641 AH.$194.met1 VDD.$350.met1 0.00183333f
Cext_642 AH.$194.met1 VDD.$375.met1 0.00238554f
Cext_643 AH.$194.met1 VDD.$49.li1 0.0066848f
Cext_644 AH.$194.met1 VDD.$667.nwell 0.00211832f
Cext_645 AH.$194.met1 sky130_gnd 0.00649879f
Cext_646 AH.$195.met1 PB.P0.poly 0.0150866f
Cext_647 AH.$195.met1 VDD.$351.met1 0.00183333f
Cext_648 AH.$195.met1 VDD.$376.met1 0.00238554f
Cext_649 AH.$195.met1 VDD.$50.li1 0.0066848f
Cext_650 AH.$195.met1 VDD.$668.nwell 0.00211832f
Cext_651 AH.$195.met1 sky130_gnd 0.00649879f
Cext_652 AH.$196.met1 PB.P0.poly 0.0151301f
Cext_653 AH.$196.met1 VDD.$352.met1 0.00183333f
Cext_654 AH.$196.met1 VDD.$377.met1 0.00238554f
Cext_655 AH.$196.met1 VDD.$51.li1 0.0066848f
Cext_656 AH.$196.met1 VDD.$669.nwell 0.00211832f
Cext_657 AH.$196.met1 sky130_gnd 0.00649879f
Cext_658 AH.$197.met1 PB.P0.poly 0.0151301f
Cext_659 AH.$197.met1 VDD.$353.met1 0.00183333f
Cext_660 AH.$197.met1 VDD.$378.met1 0.00238554f
Cext_661 AH.$197.met1 VDD.$52.li1 0.0071244f
Cext_662 AH.$197.met1 VDD.$670.nwell 0.00167872f
Cext_663 AH.$197.met1 sky130_gnd 0.00649879f
Cext_664 AH.$198.met1 PB.P0.poly 0.0151301f
Cext_665 AH.$198.met1 VDD.$354.met1 0.00183333f
Cext_666 AH.$198.met1 VDD.$379.met1 0.00238554f
Cext_667 AH.$198.met1 VDD.$53.li1 0.00715567f
Cext_668 AH.$198.met1 VDD.$671.nwell 0.00158074f
Cext_669 AH.$198.met1 sky130_gnd 0.00649879f
Cext_670 AH.$199.met1 PB.P0.poly 0.0150079f
Cext_671 AH.$199.met1 VDD.$355.met1 0.00183333f
Cext_672 AH.$199.met1 VDD.$367.met1 0.00427598f
Cext_673 AH.$199.met1 VDD.$380.met1 0.0013253f
Cext_674 AH.$199.met1 VDD.$478.met2 0.00188181f
Cext_675 AH.$199.met1 VDD.$54.li1 0.00536591f
Cext_676 AH.$199.met1 VDD.$66.li1 0.0034867f
Cext_677 AH.$199.met1 sky130_gnd 0.00361044f
Cext_678 AH.$200.met1 PB.P0.poly 0.0149101f
Cext_679 AH.$200.met1 VDD.$356.met1 0.00183333f
Cext_680 AH.$200.met1 VDD.$367.met1 0.00409302f
Cext_681 AH.$200.met1 VDD.$381.met1 0.0013253f
Cext_682 AH.$200.met1 VDD.$478.met2 0.00375313f
Cext_683 AH.$200.met1 VDD.$55.li1 0.00534346f
Cext_684 AH.$200.met1 VDD.$66.li1 0.0034867f
Cext_685 AH.$200.met1 sky130_gnd 0.00361044f
Cext_686 AH.$201.met1 PB.$5934.met3 0.00534809f
Cext_687 AH.$201.met1 PB.P0.poly 0.0150514f
Cext_688 AH.$201.met1 VDD.$357.met1 0.00183333f
Cext_689 AH.$201.met1 VDD.$382.met1 0.00238554f
Cext_690 AH.$201.met1 VDD.$478.met2 0.00158821f
Cext_691 AH.$201.met1 VDD.$501.met3 0.00584459f
Cext_692 AH.$201.met1 VDD.$56.li1 0.00699281f
Cext_693 AH.$201.met1 VDD.$674.nwell 0.00158074f
Cext_694 AH.$201.met1 sky130_gnd 0.00649879f
Cext_695 AH.$202.met1 PB.$5934.met3 0.00598055f
Cext_696 AH.$202.met1 PB.P0.poly 0.0151413f
Cext_697 AH.$202.met1 VDD.$358.met1 0.00183333f
Cext_698 AH.$202.met1 VDD.$383.met1 0.00238554f
Cext_699 AH.$202.met1 VDD.$501.met3 0.00636797f
Cext_700 AH.$202.met1 VDD.$57.li1 0.00691448f
Cext_701 AH.$202.met1 VDD.$675.nwell 0.00167872f
Cext_702 AH.$202.met1 sky130_gnd 0.00649879f
Cext_703 AH.$203.met1 PB.P0.poly 0.0151413f
Cext_704 AH.$203.met1 VDD.$359.met1 0.00183333f
Cext_705 AH.$203.met1 VDD.$384.met1 0.00238554f
Cext_706 AH.$203.met1 VDD.$58.li1 0.00647487f
Cext_707 AH.$203.met1 VDD.$676.nwell 0.00211832f
Cext_708 AH.$203.met1 sky130_gnd 0.00649879f
Cext_709 AH.$204.met1 PB.P0.poly 0.0150979f
Cext_710 AH.$204.met1 VDD.$360.met1 0.00183333f
Cext_711 AH.$204.met1 VDD.$385.met1 0.00238554f
Cext_712 AH.$204.met1 VDD.$59.li1 0.00647487f
Cext_713 AH.$204.met1 VDD.$677.nwell 0.00211832f
Cext_714 AH.$204.met1 sky130_gnd 0.00649879f
Cext_715 AH.$205.met1 PB.P0.poly 0.0149214f
Cext_716 AH.$205.met1 VDD.$361.met1 0.00183333f
Cext_717 AH.$205.met1 VDD.$386.met1 0.00238554f
Cext_718 AH.$205.met1 VDD.$60.li1 0.00647487f
Cext_719 AH.$205.met1 VDD.$678.nwell 0.00211832f
Cext_720 AH.$205.met1 sky130_gnd 0.00649879f
Cext_721 AH.$206.met1 PB.$11469.poly 0.0142094f
Cext_722 AH.$206.met1 VDD.$362.met1 0.00183333f
Cext_723 AH.$206.met1 VDD.$387.met1 0.00238554f
Cext_724 AH.$206.met1 VDD.$61.li1 0.00647487f
Cext_725 AH.$206.met1 VDD.$679.nwell 0.00211832f
Cext_726 AH.$206.met1 sky130_gnd 0.00649879f
Cext_727 AH.$207.met1 PB.$11469.poly 0.0151413f
Cext_728 AH.$207.met1 VDD.$363.met1 0.00183333f
Cext_729 AH.$207.met1 VDD.$388.met1 0.00238554f
Cext_730 AH.$207.met1 VDD.$62.li1 0.00647487f
Cext_731 AH.$207.met1 VDD.$680.nwell 0.00211832f
Cext_732 AH.$207.met1 sky130_gnd 0.00649879f
Cext_733 AH.$208.met1 PB.$11469.poly 0.0151413f
Cext_734 AH.$208.met1 VDD.$364.met1 0.00183333f
Cext_735 AH.$208.met1 VDD.$389.met1 0.00238554f
Cext_736 AH.$208.met1 VDD.$63.li1 0.00647487f
Cext_737 AH.$208.met1 VDD.$681.nwell 0.00211832f
Cext_738 AH.$208.met1 sky130_gnd 0.00649879f
Cext_739 AH.$209.met1 PB.$11469.poly 0.0151413f
Cext_740 AH.$209.met1 VDD.$365.met1 0.00183333f
Cext_741 AH.$209.met1 VDD.$390.met1 0.00238554f
Cext_742 AH.$209.met1 VDD.$64.li1 0.00647487f
Cext_743 AH.$209.met1 VDD.$682.nwell 0.00211832f
Cext_744 AH.$209.met1 sky130_gnd 0.00649879f
Cext_745 AH.$210.met1 PB.$11469.poly 0.0136692f
Cext_746 AH.$210.met1 PB.$5934.met3 0.00128302f
Cext_747 AH.$210.met1 VDD.$366.met1 0.00165509f
Cext_748 AH.$210.met1 VDD.$391.met1 0.00215361f
Cext_749 AH.$210.met1 VDD.$65.li1 0.00584537f
Cext_750 AH.$210.met1 VDD.$683.nwell 0.00436503f
Cext_751 AH.$210.met1 sky130_gnd 0.0124752f
Cext_752 AH.$211.met1 VDD.$369.met1 0.00235252f
Cext_753 AH.$211.met1 VDD.$44.li1 0.00848463f
Cext_754 AH.$211.met1 VDD.$45.li1 0.00118832f
Cext_755 AH.$211.met1 VDD.$55.li1 0.00406404f
Cext_756 AH.$211.met1 VDD.$662.nwell 0.00287526f
Cext_757 AH.$211.met1 sky130_gnd 0.00927093f
Cext_758 AH.$212.met1 BH.$210.met1 0.00138251f
Cext_759 AH.$212.met1 TAIL.$336.met2 0.00171135f
Cext_760 AH.$212.met1 sky130_gnd 0.00962382f
Cext_761 AH.$213.met1 BH.$211.met1 0.00138251f
Cext_762 AH.$213.met1 sky130_gnd 0.0180031f
Cext_763 AH.$214.met1 sky130_gnd 0.0196074f
Cext_764 AH.$215.met1 TAIL.$340.met3 0.00254253f
Cext_765 AH.$215.met1 sky130_gnd 0.0125297f
Cext_766 AH.$216.met1 sky130_gnd 0.0120458f
Cext_767 AH.$217.met1 TAIL.$340.met3 0.00333784f
Cext_768 AH.$217.met1 sky130_gnd 0.0143234f
Cext_769 AH.$218.met1 PB.$5789.met1 0.00232088f
Cext_770 AH.$218.met1 sky130_gnd 0.0120458f
Cext_771 AH.$219.met1 TAIL.$340.met3 0.00366379f
Cext_772 AH.$219.met1 sky130_gnd 0.0143234f
Cext_773 AH.$220.met1 PB.$5792.met1 0.00116044f
Cext_774 AH.$220.met1 sky130_gnd 0.0120458f
Cext_775 AH.$221.met1 TAIL.$340.met3 0.0033264f
Cext_776 AH.$221.met1 sky130_gnd 0.0143234f
Cext_777 AH.$222.met1 PB.$5794.met1 0.00174066f
Cext_778 AH.$222.met1 sky130_gnd 0.0120458f
Cext_779 AH.$223.met1 TAIL.$340.met3 0.00342933f
Cext_780 AH.$223.met1 sky130_gnd 0.0143234f
Cext_781 AH.$224.met1 PB.$5796.met1 0.00232088f
Cext_782 AH.$224.met1 sky130_gnd 0.0120458f
Cext_783 AH.$225.met1 NB.$275.met3 0.00137234f
Cext_784 AH.$225.met1 PB.$5920.met2 0.0114587f
Cext_785 AH.$225.met1 TAIL.$340.met3 0.00364663f
Cext_786 AH.$225.met1 sky130_gnd 0.0143234f
Cext_787 AH.$226.met1 PB.$5798.met1 0.00116044f
Cext_788 AH.$226.met1 sky130_gnd 0.0120458f
Cext_789 AH.$227.met1 TAIL.$340.met3 0.00325206f
Cext_790 AH.$227.met1 sky130_gnd 0.0143234f
Cext_791 AH.$228.met1 PB.$5800.met1 0.00174066f
Cext_792 AH.$228.met1 sky130_gnd 0.0120458f
Cext_793 AH.$229.met1 TAIL.$340.met3 0.00352083f
Cext_794 AH.$229.met1 sky130_gnd 0.0143234f
Cext_795 AH.$230.met1 PB.$5802.met1 0.00116044f
Cext_796 AH.$230.met1 sky130_gnd 0.0120458f
Cext_797 AH.$231.met1 TAIL.$340.met3 0.00355514f
Cext_798 AH.$231.met1 sky130_gnd 0.0143234f
Cext_799 AH.$232.met1 PB.$5804.met1 0.00232088f
Cext_800 AH.$232.met1 sky130_gnd 0.0120458f
Cext_801 AH.$233.met1 NB.$176.met1 0.00138251f
Cext_802 AH.$233.met1 PB.$5920.met2 0.00452293f
Cext_803 AH.$233.met1 TAIL.$340.met3 0.00293589f
Cext_804 AH.$233.met1 sky130_gnd 0.0200593f
Cext_805 AH.$234.met1 sky130_gnd 0.0200078f
Cext_806 AH.$235.met2 BH.$161.met1 0.0053986f
Cext_807 AH.$235.met2 BH.$235.met2 0.149081f
Cext_808 AH.$235.met2 BH.$237.met2 0.046035f
Cext_809 AH.$235.met2 BH.$24.li1 0.00408784f
Cext_810 AH.$235.met2 BH.$247.poly 0.00265375f
Cext_811 AH.$235.met2 TAIL.$339.met3 0.00531958f
Cext_812 AH.$235.met2 sky130_gnd 0.247611f
Cext_813 AH.$236.met2 BH.$236.met2 0.00284091f
Cext_814 AH.$236.met2 BH.$241.met3 0.0277297f
Cext_815 AH.$236.met2 PB.$11468.poly 0.0135027f
Cext_816 AH.$236.met2 VDD.$501.met3 0.00203861f
Cext_817 AH.$236.met2 VDD.$662.nwell 0.00228594f
Cext_818 AH.$236.met2 sky130_gnd 0.0077805f
Cext_819 AH.$237.met2 BH.$161.met1 0.00159689f
Cext_820 AH.$237.met2 BH.$170.met1 0.0131254f
Cext_821 AH.$237.met2 BH.$180.met1 0.00849818f
Cext_822 AH.$237.met2 BH.$190.met1 0.024506f
Cext_823 AH.$237.met2 BH.$200.met1 0.0159948f
Cext_824 AH.$237.met2 BH.$202.met1 0.0159948f
Cext_825 AH.$237.met2 BH.$204.met1 0.0159948f
Cext_826 AH.$237.met2 BH.$206.met1 0.0159948f
Cext_827 AH.$237.met2 BH.$208.met1 0.0159948f
Cext_828 AH.$237.met2 BH.$210.met1 0.0250693f
Cext_829 AH.$237.met2 BH.$235.met2 0.0203378f
Cext_830 AH.$237.met2 BH.$238.met2 0.0448249f
Cext_831 AH.$237.met2 BH.$247.poly 0.173589f
Cext_832 AH.$237.met2 BH.$48.li1 0.00175354f
Cext_833 AH.$237.met2 BH.$60.li1 0.00352633f
Cext_834 AH.$237.met2 BH.$92.li1 0.00448478f
Cext_835 AH.$237.met2 BH.P0.poly 0.0723865f
Cext_836 AH.$237.met2 N1 0.019571f
Cext_837 AH.$237.met2 N1.$198.met1 0.00543987f
Cext_838 AH.$237.met2 N1.$242.met1 0.00105802f
Cext_839 AH.$237.met2 N1.$301.met2 0.0101951f
Cext_840 AH.$237.met2 N1.$302.met2 0.00921053f
Cext_841 AH.$237.met2 N1.$308.met3 0.111416f
Cext_842 AH.$237.met2 N1.P0.nsdm 0.00587861f
Cext_843 AH.$237.met2 PB.$5920.met2 0.00303571f
Cext_844 AH.$237.met2 PB.P1.nsdm 0.00138376f
Cext_845 AH.$237.met2 TAIL.$100.li1 0.001468f
Cext_846 AH.$237.met2 TAIL.$102.li1 0.001468f
Cext_847 AH.$237.met2 TAIL.$104.li1 0.001468f
Cext_848 AH.$237.met2 TAIL.$106.li1 0.001468f
Cext_849 AH.$237.met2 TAIL.$108.li1 0.001468f
Cext_850 AH.$237.met2 TAIL.$110.li1 0.001468f
Cext_851 AH.$237.met2 TAIL.$112.li1 0.001468f
Cext_852 AH.$237.met2 TAIL.$114.li1 0.001468f
Cext_853 AH.$237.met2 TAIL.$116.li1 0.001468f
Cext_854 AH.$237.met2 TAIL.$118.li1 0.001468f
Cext_855 AH.$237.met2 TAIL.$120.li1 0.001468f
Cext_856 AH.$237.met2 TAIL.$122.li1 0.001468f
Cext_857 AH.$237.met2 TAIL.$124.li1 0.001468f
Cext_858 AH.$237.met2 TAIL.$126.li1 0.001468f
Cext_859 AH.$237.met2 TAIL.$128.li1 0.001468f
Cext_860 AH.$237.met2 TAIL.$130.li1 0.00136605f
Cext_861 AH.$237.met2 TAIL.$132.li1 0.00140683f
Cext_862 AH.$237.met2 TAIL.$134.li1 0.001468f
Cext_863 AH.$237.met2 TAIL.$136.li1 0.001468f
Cext_864 AH.$237.met2 TAIL.$138.li1 0.001468f
Cext_865 AH.$237.met2 TAIL.$140.li1 0.001468f
Cext_866 AH.$237.met2 TAIL.$142.li1 0.001468f
Cext_867 AH.$237.met2 TAIL.$144.li1 0.001468f
Cext_868 AH.$237.met2 TAIL.$265.met1 0.00860485f
Cext_869 AH.$237.met2 TAIL.$266.met1 0.00550467f
Cext_870 AH.$237.met2 TAIL.$267.met1 0.0100275f
Cext_871 AH.$237.met2 TAIL.$268.met1 0.0100275f
Cext_872 AH.$237.met2 TAIL.$269.met1 0.0100275f
Cext_873 AH.$237.met2 TAIL.$270.met1 0.0100275f
Cext_874 AH.$237.met2 TAIL.$271.met1 0.0100275f
Cext_875 AH.$237.met2 TAIL.$272.met1 0.0100275f
Cext_876 AH.$237.met2 TAIL.$273.met1 0.0100275f
Cext_877 AH.$237.met2 TAIL.$274.met1 0.0100275f
Cext_878 AH.$237.met2 TAIL.$275.met1 0.0100275f
Cext_879 AH.$237.met2 TAIL.$276.met1 0.0100275f
Cext_880 AH.$237.met2 TAIL.$277.met1 0.0100275f
Cext_881 AH.$237.met2 TAIL.$278.met1 0.0100275f
Cext_882 AH.$237.met2 TAIL.$279.met1 0.0100275f
Cext_883 AH.$237.met2 TAIL.$280.met1 0.0100275f
Cext_884 AH.$237.met2 TAIL.$281.met1 0.0100275f
Cext_885 AH.$237.met2 TAIL.$282.met1 0.0100275f
Cext_886 AH.$237.met2 TAIL.$283.met1 0.0100275f
Cext_887 AH.$237.met2 TAIL.$284.met1 0.0100275f
Cext_888 AH.$237.met2 TAIL.$285.met1 0.0100275f
Cext_889 AH.$237.met2 TAIL.$286.met1 0.0100275f
Cext_890 AH.$237.met2 TAIL.$287.met1 0.0100275f
Cext_891 AH.$237.met2 TAIL.$288.met1 0.0100275f
Cext_892 AH.$237.met2 TAIL.$289.met1 0.0100275f
Cext_893 AH.$237.met2 TAIL.$290.met1 0.0100275f
Cext_894 AH.$237.met2 TAIL.$291.met1 0.0100275f
Cext_895 AH.$237.met2 TAIL.$292.met1 0.0100275f
Cext_896 AH.$237.met2 TAIL.$293.met1 0.0100275f
Cext_897 AH.$237.met2 TAIL.$294.met1 0.00670636f
Cext_898 AH.$237.met2 TAIL.$335.met2 0.0195211f
Cext_899 AH.$237.met2 TAIL.$339.met3 0.052408f
Cext_900 AH.$237.met2 TAIL.$340.met3 0.135399f
Cext_901 AH.$237.met2 TAIL.$88.li1 0.00132527f
Cext_902 AH.$237.met2 TAIL.$90.li1 0.00144761f
Cext_903 AH.$237.met2 TAIL.$92.li1 0.001468f
Cext_904 AH.$237.met2 TAIL.$94.li1 0.001468f
Cext_905 AH.$237.met2 TAIL.$96.li1 0.001468f
Cext_906 AH.$237.met2 TAIL.$98.li1 0.001468f
Cext_907 AH.$237.met2 TAIL.P2.nsdm 0.00956768f
Cext_908 AH.$237.met2 VSS.$13.li1 0.00292332f
Cext_909 AH.$237.met2 VSS.$220.met1 0.00636263f
Cext_910 AH.$237.met2 VSS.$366.met2 0.02049f
Cext_911 AH.$237.met2 VSS.$368.met2 0.0070922f
Cext_912 AH.$237.met2 VSS.$376.met2 0.00248492f
Cext_913 AH.$237.met2 VSS.$377.met2 0.0181451f
Cext_914 AH.$237.met2 VSS.$379.met2 0.00980706f
Cext_915 AH.$237.met2 VSS.$415.met3 0.0656417f
Cext_916 AH.$237.met2 VSS.$417.met3 0.0173589f
Cext_917 AH.$237.met2 VSS.$6.li1 0.0294828f
Cext_918 AH.$237.met2 sky130_gnd 0.686387f
Cext_919 AH.$238.met2 PB.$5920.met2 0.00262821f
Cext_920 AH.$238.met2 TAIL.$265.met1 0.00447716f
Cext_921 AH.$238.met2 TAIL.$335.met2 0.00886478f
Cext_922 AH.$238.met2 TAIL.$336.met2 0.0108165f
Cext_923 AH.$238.met2 TAIL.$340.met3 0.00938643f
Cext_924 AH.$238.met2 sky130_gnd 0.0348454f
Cext_925 AH.$239.poly BH.$237.met2 0.00373818f
Cext_926 AH.$239.poly BH.$246.poly 0.007f
Cext_927 AH.$239.poly sky130_gnd 0.344094f
Cext_928 AH.$240.poly sky130_gnd 0.17712f
Cext_929 AH.$241.poly sky130_gnd 0.17712f
Cext_930 AH.$242.poly BH.$235.met2 0.00117013f
Cext_931 AH.$242.poly BH.$247.poly 0.00356295f
Cext_932 AH.$242.poly sky130_gnd 0.350521f
Cext_933 AH.$243.poly BH.$247.poly 0.0111132f
Cext_934 AH.$243.poly N1.$308.met3 0.0629049f
Cext_935 AH.$243.poly NB.$299.poly 0.00789103f
Cext_936 AH.$243.poly NB.P0.poly 0.00432265f
Cext_937 AH.$243.poly PB.$5560.li1 0.0172356f
Cext_938 AH.$243.poly PB.$5562.li1 0.018016f
Cext_939 AH.$243.poly PB.$5564.li1 0.0181392f
Cext_940 AH.$243.poly PB.$5566.li1 0.0181392f
Cext_941 AH.$243.poly PB.$5568.li1 0.0181392f
Cext_942 AH.$243.poly PB.$5570.li1 0.0181392f
Cext_943 AH.$243.poly PB.$5572.li1 0.0181392f
Cext_944 AH.$243.poly PB.$5574.li1 0.0181392f
Cext_945 AH.$243.poly PB.$5576.li1 0.0181392f
Cext_946 AH.$243.poly PB.$5578.li1 0.0181392f
Cext_947 AH.$243.poly PB.$5580.li1 0.00802436f
Cext_948 AH.$243.poly PB.$5808.met1 0.0134534f
Cext_949 AH.$243.poly PB.$5809.met1 0.0148526f
Cext_950 AH.$243.poly PB.$5810.met1 0.0151239f
Cext_951 AH.$243.poly PB.$5811.met1 0.0150995f
Cext_952 AH.$243.poly PB.$5812.met1 0.0151115f
Cext_953 AH.$243.poly PB.$5813.met1 0.0151919f
Cext_954 AH.$243.poly PB.$5814.met1 0.0151919f
Cext_955 AH.$243.poly PB.$5815.met1 0.0151919f
Cext_956 AH.$243.poly PB.$5816.met1 0.0151919f
Cext_957 AH.$243.poly PB.$5817.met1 0.0151369f
Cext_958 AH.$243.poly PB.$5818.met1 0.00574371f
Cext_959 AH.$243.poly PB.$5920.met2 0.0487474f
Cext_960 AH.$243.poly TAIL.$100.li1 0.0181392f
Cext_961 AH.$243.poly TAIL.$102.li1 0.0181392f
Cext_962 AH.$243.poly TAIL.$104.li1 0.0181392f
Cext_963 AH.$243.poly TAIL.$106.li1 0.0181392f
Cext_964 AH.$243.poly TAIL.$108.li1 0.00802436f
Cext_965 AH.$243.poly TAIL.$265.met1 0.0114847f
Cext_966 AH.$243.poly TAIL.$266.met1 0.003117f
Cext_967 AH.$243.poly TAIL.$267.met1 0.0151239f
Cext_968 AH.$243.poly TAIL.$268.met1 0.0150995f
Cext_969 AH.$243.poly TAIL.$269.met1 0.0150995f
Cext_970 AH.$243.poly TAIL.$270.met1 0.0151301f
Cext_971 AH.$243.poly TAIL.$271.met1 0.0151301f
Cext_972 AH.$243.poly TAIL.$272.met1 0.0151301f
Cext_973 AH.$243.poly TAIL.$273.met1 0.0151301f
Cext_974 AH.$243.poly TAIL.$274.met1 0.0151301f
Cext_975 AH.$243.poly TAIL.$275.met1 0.00591478f
Cext_976 AH.$243.poly TAIL.$309.met1 0.0190108f
Cext_977 AH.$243.poly TAIL.$335.met2 0.00111149f
Cext_978 AH.$243.poly TAIL.$336.met2 0.0220001f
Cext_979 AH.$243.poly TAIL.$340.met3 0.0855443f
Cext_980 AH.$243.poly TAIL.$341.met3 0.00168414f
Cext_981 AH.$243.poly TAIL.$88.li1 0.0179629f
Cext_982 AH.$243.poly TAIL.$90.li1 0.0181146f
Cext_983 AH.$243.poly TAIL.$92.li1 0.0181392f
Cext_984 AH.$243.poly TAIL.$94.li1 0.0181392f
Cext_985 AH.$243.poly TAIL.$96.li1 0.0181392f
Cext_986 AH.$243.poly TAIL.$98.li1 0.0181392f
Cext_987 AH.$243.poly VSS.$24.li1 0.0010312f
Cext_988 AH.$243.poly VSS.$26.li1 0.0010312f
Cext_989 AH.$243.poly VSS.$28.li1 0.0010312f
Cext_990 AH.$243.poly VSS.$30.li1 0.0010312f
Cext_991 AH.$243.poly VSS.$377.met2 0.00209284f
Cext_992 AH.$243.poly VSS.$379.met2 0.0418092f
Cext_993 AH.$243.poly sky130_gnd 0.501448f
Cext_994 AH.$244.poly BH.$242.met3 0.025749f
Cext_995 AH.$244.poly BH.$248.poly 0.0111132f
Cext_996 AH.$244.poly PB.$11490.poly 0.00670476f
Cext_997 AH.$244.poly PB.$5626.li1 0.00802436f
Cext_998 AH.$244.poly PB.$5628.li1 0.0189343f
Cext_999 AH.$244.poly PB.$5630.li1 0.0181392f
Cext_1000 AH.$244.poly PB.$5632.li1 0.0181392f
Cext_1001 AH.$244.poly PB.$5634.li1 0.0181392f
Cext_1002 AH.$244.poly PB.$5636.li1 0.0181392f
Cext_1003 AH.$244.poly PB.$5638.li1 0.0181392f
Cext_1004 AH.$244.poly PB.$5640.li1 0.0181392f
Cext_1005 AH.$244.poly PB.$5642.li1 0.0181392f
Cext_1006 AH.$244.poly PB.$5644.li1 0.0181392f
Cext_1007 AH.$244.poly PB.$5646.li1 0.0172849f
Cext_1008 AH.$244.poly PB.$5841.met1 0.00591478f
Cext_1009 AH.$244.poly PB.$5842.met1 0.0151919f
Cext_1010 AH.$244.poly PB.$5843.met1 0.0151919f
Cext_1011 AH.$244.poly PB.$5844.met1 0.0151919f
Cext_1012 AH.$244.poly PB.$5845.met1 0.0151919f
Cext_1013 AH.$244.poly PB.$5846.met1 0.0151919f
Cext_1014 AH.$244.poly PB.$5847.met1 0.0151919f
Cext_1015 AH.$244.poly PB.$5848.met1 0.0151919f
Cext_1016 AH.$244.poly PB.$5849.met1 0.0151919f
Cext_1017 AH.$244.poly PB.$5850.met1 0.0151919f
Cext_1018 AH.$244.poly PB.$5851.met1 0.013715f
Cext_1019 AH.$244.poly TAIL.$154.li1 0.00802436f
Cext_1020 AH.$244.poly TAIL.$156.li1 0.0182178f
Cext_1021 AH.$244.poly TAIL.$158.li1 0.0181392f
Cext_1022 AH.$244.poly TAIL.$160.li1 0.0181392f
Cext_1023 AH.$244.poly TAIL.$162.li1 0.0181392f
Cext_1024 AH.$244.poly TAIL.$164.li1 0.0181392f
Cext_1025 AH.$244.poly TAIL.$166.li1 0.0181392f
Cext_1026 AH.$244.poly TAIL.$168.li1 0.0181392f
Cext_1027 AH.$244.poly TAIL.$170.li1 0.0181392f
Cext_1028 AH.$244.poly TAIL.$172.li1 0.0181392f
Cext_1029 AH.$244.poly TAIL.$174.li1 0.0172849f
Cext_1030 AH.$244.poly TAIL.$298.met1 0.00591478f
Cext_1031 AH.$244.poly TAIL.$299.met1 0.0151301f
Cext_1032 AH.$244.poly TAIL.$300.met1 0.0151301f
Cext_1033 AH.$244.poly TAIL.$301.met1 0.0151301f
Cext_1034 AH.$244.poly TAIL.$302.met1 0.0151301f
Cext_1035 AH.$244.poly TAIL.$303.met1 0.0151301f
Cext_1036 AH.$244.poly TAIL.$304.met1 0.0151301f
Cext_1037 AH.$244.poly TAIL.$305.met1 0.0151301f
Cext_1038 AH.$244.poly TAIL.$306.met1 0.0151301f
Cext_1039 AH.$244.poly TAIL.$307.met1 0.0151301f
Cext_1040 AH.$244.poly TAIL.$308.met1 0.0136591f
Cext_1041 AH.$244.poly VDD.$480.met2 0.00181375f
Cext_1042 AH.$244.poly VSS.$13.li1 0.0107009f
Cext_1043 AH.$244.poly sky130_gnd 0.494555f
Cext_1044 AH.$52.li1 BH.$241.met3 0.00340629f
Cext_1045 AH.$52.li1 PB.$11468.poly 0.017211f
Cext_1046 AH.$52.li1 VDD.$0.li1 0.00103015f
Cext_1047 AH.$52.li1 VDD.$44.li1 0.0161652f
Cext_1048 AH.$52.li1 VDD.$662.nwell 0.00236608f
Cext_1049 AH.$52.li1 sky130_gnd 0.00394985f
Cext_1050 AH.$54.li1 BH.$241.met3 0.00123644f
Cext_1051 AH.$54.li1 PB.$11468.poly 0.0181392f
Cext_1052 AH.$54.li1 VDD.$2.li1 0.00107494f
Cext_1053 AH.$54.li1 VDD.$45.li1 0.0166429f
Cext_1054 AH.$56.li1 PB.$11468.poly 0.0192476f
Cext_1055 AH.$56.li1 VDD.$4.li1 0.00107494f
Cext_1056 AH.$56.li1 VDD.$46.li1 0.0169988f
Cext_1057 AH.$58.li1 PB.$11468.poly 0.0181392f
Cext_1058 AH.$58.li1 VDD.$47.li1 0.0166429f
Cext_1059 AH.$58.li1 VDD.$500.met3 0.00436347f
Cext_1060 AH.$58.li1 VDD.$6.li1 0.00107494f
Cext_1061 AH.$60.li1 PB.$11468.poly 0.0171523f
Cext_1062 AH.$60.li1 PB.P0.poly 0.00102285f
Cext_1063 AH.$60.li1 VDD.$48.li1 0.0170333f
Cext_1064 AH.$60.li1 VDD.$8.li1 0.00107494f
Cext_1065 AH.$62.li1 PB.$11468.poly 0.00177361f
Cext_1066 AH.$62.li1 PB.P0.poly 0.0164102f
Cext_1067 AH.$62.li1 VDD.$10.li1 0.00107494f
Cext_1068 AH.$62.li1 VDD.$49.li1 0.0166857f
Cext_1069 AH.$64.li1 PB.P0.poly 0.0178335f
Cext_1070 AH.$64.li1 VDD.$12.li1 0.00107494f
Cext_1071 AH.$64.li1 VDD.$50.li1 0.0166857f
Cext_1072 AH.$66.li1 PB.P0.poly 0.0181838f
Cext_1073 AH.$66.li1 VDD.$14.li1 0.00107494f
Cext_1074 AH.$66.li1 VDD.$51.li1 0.0166857f
Cext_1075 AH.$68.li1 PB.P0.poly 0.0181838f
Cext_1076 AH.$68.li1 VDD.$16.li1 0.00107494f
Cext_1077 AH.$68.li1 VDD.$52.li1 0.0166857f
Cext_1078 AH.$70.li1 PB.P0.poly 0.0181838f
Cext_1079 AH.$70.li1 VDD.$18.li1 0.00107494f
Cext_1080 AH.$70.li1 VDD.$53.li1 0.0166857f
Cext_1081 AH.$72.li1 PB.P0.poly 0.0180851f
Cext_1082 AH.$72.li1 VDD.$20.li1 0.00107494f
Cext_1083 AH.$72.li1 VDD.$54.li1 0.0153482f
Cext_1084 AH.$72.li1 VDD.$66.li1 0.0012197f
Cext_1085 AH.$74.li1 PB.P0.poly 0.0180653f
Cext_1086 AH.$74.li1 VDD.$22.li1 0.00107494f
Cext_1087 AH.$74.li1 VDD.$55.li1 0.0153482f
Cext_1088 AH.$74.li1 VDD.$66.li1 0.0012197f
Cext_1089 AH.$76.li1 PB.P0.poly 0.0181665f
Cext_1090 AH.$76.li1 VDD.$24.li1 0.00107494f
Cext_1091 AH.$76.li1 VDD.$56.li1 0.0166857f
Cext_1092 AH.$78.li1 PB.P0.poly 0.0181838f
Cext_1093 AH.$78.li1 VDD.$26.li1 0.00107494f
Cext_1094 AH.$78.li1 VDD.$57.li1 0.0166857f
Cext_1095 AH.$80.li1 PB.P0.poly 0.0200476f
Cext_1096 AH.$80.li1 VDD.$28.li1 0.00107494f
Cext_1097 AH.$80.li1 VDD.$58.li1 0.0166857f
Cext_1098 AH.$82.li1 PB.P0.poly 0.0178335f
Cext_1099 AH.$82.li1 VDD.$30.li1 0.00107494f
Cext_1100 AH.$82.li1 VDD.$59.li1 0.0166857f
Cext_1101 AH.$84.li1 PB.$11469.poly 0.00177361f
Cext_1102 AH.$84.li1 PB.P0.poly 0.0164102f
Cext_1103 AH.$84.li1 VDD.$32.li1 0.00107494f
Cext_1104 AH.$84.li1 VDD.$60.li1 0.0166857f
Cext_1105 AH.$86.li1 PB.$11469.poly 0.0171609f
Cext_1106 AH.$86.li1 PB.P0.poly 0.00102285f
Cext_1107 AH.$86.li1 VDD.$34.li1 0.00107494f
Cext_1108 AH.$86.li1 VDD.$61.li1 0.0166857f
Cext_1109 AH.$88.li1 PB.$11469.poly 0.0181838f
Cext_1110 AH.$88.li1 VDD.$36.li1 0.00107494f
Cext_1111 AH.$88.li1 VDD.$62.li1 0.0166857f
Cext_1112 AH.$90.li1 PB.$11469.poly 0.0187975f
Cext_1113 AH.$90.li1 VDD.$38.li1 0.00107494f
Cext_1114 AH.$90.li1 VDD.$63.li1 0.0166857f
Cext_1115 AH.$92.li1 PB.$11469.poly 0.0181838f
Cext_1116 AH.$92.li1 VDD.$40.li1 0.00107494f
Cext_1117 AH.$92.li1 VDD.$64.li1 0.0166857f
Cext_1118 AH.$94.li1 PB.$11469.poly 0.0176936f
Cext_1119 AH.$94.li1 VDD.$42.li1 0.00103015f
Cext_1120 AH.$94.li1 VDD.$65.li1 0.015873f
Cext_1121 AH.$94.li1 VDD.$683.nwell 0.00236608f
Cext_1122 AH.$94.li1 sky130_gnd 0.00435263f
Cext_1123 AH.$96.li1 sky130_gnd 0.0191686f
Cext_1124 AH.$98.li1 sky130_gnd 0.0176493f
Cext_1125 AH.P0.poly BH.P0.poly 0.0191311f
Cext_1126 AH.P0.poly N1.$308.met3 0.170644f
Cext_1127 AH.P0.poly NB.$300.poly 0.00771326f
Cext_1128 AH.P0.poly NB.P0.poly 0.00405986f
Cext_1129 AH.P0.poly PB.$5580.li1 0.0101148f
Cext_1130 AH.P0.poly PB.$5582.li1 0.0180692f
Cext_1131 AH.P0.poly PB.$5584.li1 0.0181392f
Cext_1132 AH.P0.poly PB.$5586.li1 0.0181392f
Cext_1133 AH.P0.poly PB.$5588.li1 0.0181392f
Cext_1134 AH.P0.poly PB.$5590.li1 0.0181392f
Cext_1135 AH.P0.poly PB.$5592.li1 0.0181392f
Cext_1136 AH.P0.poly PB.$5594.li1 0.0181392f
Cext_1137 AH.P0.poly PB.$5596.li1 0.0181392f
Cext_1138 AH.P0.poly PB.$5598.li1 0.0181392f
Cext_1139 AH.P0.poly PB.$5600.li1 0.0181392f
Cext_1140 AH.P0.poly PB.$5602.li1 0.0179668f
Cext_1141 AH.P0.poly PB.$5604.li1 0.0180653f
Cext_1142 AH.P0.poly PB.$5606.li1 0.0181392f
Cext_1143 AH.P0.poly PB.$5608.li1 0.0181392f
Cext_1144 AH.P0.poly PB.$5610.li1 0.0181392f
Cext_1145 AH.P0.poly PB.$5612.li1 0.0181392f
Cext_1146 AH.P0.poly PB.$5614.li1 0.0181392f
Cext_1147 AH.P0.poly PB.$5616.li1 0.0181392f
Cext_1148 AH.P0.poly PB.$5618.li1 0.0181392f
Cext_1149 AH.P0.poly PB.$5620.li1 0.0181392f
Cext_1150 AH.P0.poly PB.$5622.li1 0.0181392f
Cext_1151 AH.P0.poly PB.$5624.li1 0.0180692f
Cext_1152 AH.P0.poly PB.$5626.li1 0.0101148f
Cext_1153 AH.P0.poly PB.$5818.met1 0.00926341f
Cext_1154 AH.P0.poly PB.$5819.met1 0.0151278f
Cext_1155 AH.P0.poly PB.$5820.met1 0.0151919f
Cext_1156 AH.P0.poly PB.$5821.met1 0.0151919f
Cext_1157 AH.P0.poly PB.$5822.met1 0.0151919f
Cext_1158 AH.P0.poly PB.$5823.met1 0.0151919f
Cext_1159 AH.P0.poly PB.$5824.met1 0.0151919f
Cext_1160 AH.P0.poly PB.$5825.met1 0.0151919f
Cext_1161 AH.P0.poly PB.$5826.met1 0.0151919f
Cext_1162 AH.P0.poly PB.$5827.met1 0.0151919f
Cext_1163 AH.P0.poly PB.$5828.met1 0.0151047f
Cext_1164 AH.P0.poly PB.$5829.met1 0.0149834f
Cext_1165 AH.P0.poly PB.$5830.met1 0.0149101f
Cext_1166 AH.P0.poly PB.$5831.met1 0.0150589f
Cext_1167 AH.P0.poly PB.$5832.met1 0.0151919f
Cext_1168 AH.P0.poly PB.$5833.met1 0.0151919f
Cext_1169 AH.P0.poly PB.$5834.met1 0.0151919f
Cext_1170 AH.P0.poly PB.$5835.met1 0.0151919f
Cext_1171 AH.P0.poly PB.$5836.met1 0.0151919f
Cext_1172 AH.P0.poly PB.$5837.met1 0.0151919f
Cext_1173 AH.P0.poly PB.$5838.met1 0.0151919f
Cext_1174 AH.P0.poly PB.$5839.met1 0.0151919f
Cext_1175 AH.P0.poly PB.$5840.met1 0.0151833f
Cext_1176 AH.P0.poly PB.$5841.met1 0.00921527f
Cext_1177 AH.P0.poly TAIL.$108.li1 0.0101148f
Cext_1178 AH.P0.poly TAIL.$110.li1 0.0180692f
Cext_1179 AH.P0.poly TAIL.$112.li1 0.0181392f
Cext_1180 AH.P0.poly TAIL.$114.li1 0.0181392f
Cext_1181 AH.P0.poly TAIL.$116.li1 0.0181392f
Cext_1182 AH.P0.poly TAIL.$118.li1 0.0181392f
Cext_1183 AH.P0.poly TAIL.$120.li1 0.0181392f
Cext_1184 AH.P0.poly TAIL.$122.li1 0.0181392f
Cext_1185 AH.P0.poly TAIL.$124.li1 0.0181392f
Cext_1186 AH.P0.poly TAIL.$126.li1 0.0181392f
Cext_1187 AH.P0.poly TAIL.$128.li1 0.0181392f
Cext_1188 AH.P0.poly TAIL.$130.li1 0.018016f
Cext_1189 AH.P0.poly TAIL.$132.li1 0.0180653f
Cext_1190 AH.P0.poly TAIL.$134.li1 0.0181392f
Cext_1191 AH.P0.poly TAIL.$136.li1 0.0181392f
Cext_1192 AH.P0.poly TAIL.$138.li1 0.0181392f
Cext_1193 AH.P0.poly TAIL.$140.li1 0.0181392f
Cext_1194 AH.P0.poly TAIL.$142.li1 0.0181392f
Cext_1195 AH.P0.poly TAIL.$144.li1 0.0181392f
Cext_1196 AH.P0.poly TAIL.$146.li1 0.0186622f
Cext_1197 AH.P0.poly TAIL.$148.li1 0.0181392f
Cext_1198 AH.P0.poly TAIL.$150.li1 0.0181392f
Cext_1199 AH.P0.poly TAIL.$152.li1 0.0180692f
Cext_1200 AH.P0.poly TAIL.$154.li1 0.0101148f
Cext_1201 AH.P0.poly TAIL.$275.met1 0.00921527f
Cext_1202 AH.P0.poly TAIL.$276.met1 0.0151214f
Cext_1203 AH.P0.poly TAIL.$277.met1 0.0151301f
Cext_1204 AH.P0.poly TAIL.$278.met1 0.0151301f
Cext_1205 AH.P0.poly TAIL.$279.met1 0.0151301f
Cext_1206 AH.P0.poly TAIL.$280.met1 0.0151301f
Cext_1207 AH.P0.poly TAIL.$281.met1 0.0151301f
Cext_1208 AH.P0.poly TAIL.$282.met1 0.0151301f
Cext_1209 AH.P0.poly TAIL.$283.met1 0.0151301f
Cext_1210 AH.P0.poly TAIL.$284.met1 0.0151301f
Cext_1211 AH.P0.poly TAIL.$285.met1 0.0150995f
Cext_1212 AH.P0.poly TAIL.$286.met1 0.0149834f
Cext_1213 AH.P0.poly TAIL.$287.met1 0.0150079f
Cext_1214 AH.P0.poly TAIL.$288.met1 0.0151301f
Cext_1215 AH.P0.poly TAIL.$289.met1 0.0151301f
Cext_1216 AH.P0.poly TAIL.$290.met1 0.0151301f
Cext_1217 AH.P0.poly TAIL.$291.met1 0.0151301f
Cext_1218 AH.P0.poly TAIL.$292.met1 0.0151301f
Cext_1219 AH.P0.poly TAIL.$293.met1 0.0151301f
Cext_1220 AH.P0.poly TAIL.$294.met1 0.0151301f
Cext_1221 AH.P0.poly TAIL.$295.met1 0.0151301f
Cext_1222 AH.P0.poly TAIL.$296.met1 0.0151301f
Cext_1223 AH.P0.poly TAIL.$297.met1 0.0151214f
Cext_1224 AH.P0.poly TAIL.$298.met1 0.00921527f
Cext_1225 AH.P0.poly TAIL.$309.met1 0.00443851f
Cext_1226 AH.P0.poly TAIL.$335.met2 0.00445105f
Cext_1227 AH.P0.poly TAIL.$336.met2 0.0151293f
Cext_1228 AH.P0.poly VSS.$13.li1 0.0188528f
Cext_1229 AH.P0.poly VSS.$376.met2 0.0137408f
Cext_1230 AH.P0.poly VSS.$377.met2 0.0890375f
Cext_1231 AH.P0.poly VSS.$38.li1 0.0010312f
Cext_1232 AH.P0.poly VSS.$40.li1 0.0010312f
Cext_1233 AH.P0.poly VSS.$415.met3 0.116438f
Cext_1234 AH.P0.poly VSS.$417.met3 0.24904f
Cext_1235 AH.P0.poly VSS.$6.li1 0.00164028f
Cext_1236 AH.P0.psdm PB.$5934.met3 0.00270184f
Cext_1237 AH.P0.psdm VDD.$501.met3 0.00625641f
Cext_1238 AH.P1.poly sky130_gnd 0.119207f
Cext_1239 B net1.$615.met2 0.00169134f
Cext_1240 B net2.$90.met2 0.0012636f
Cext_1241 B sky130_gnd 0.0236034f
Cext_1242 B.$10.li1 sky130_gnd 0.0301038f
Cext_1243 B.$100.met1 net1.$622.met3 0.0053691f
Cext_1244 B.$100.met1 net2.$92.met3 0.0032752f
Cext_1245 B.$100.met1 VDD.$510.met3 0.0148864f
Cext_1246 B.$100.met1 VDD.$511.met3 0.00674782f
Cext_1247 B.$100.met1 sky130_gnd 0.106176f
Cext_1248 B.$101.met1 PB.$10609.met4 0.00176081f
Cext_1249 B.$101.met1 VDD.$510.met3 0.0102138f
Cext_1250 B.$101.met1 VREF.$93.met1 0.00183333f
Cext_1251 B.$101.met1 sky130_gnd 0.0255337f
Cext_1252 B.$102.met1 VREF.$106.met2 0.00135634f
Cext_1253 B.$102.met1 sky130_gnd 0.028901f
Cext_1254 B.$103.met1 VREF.$106.met2 0.00114642f
Cext_1255 B.$103.met1 sky130_gnd 0.028901f
Cext_1256 B.$104.met1 PB.$10757.met4 0.00181184f
Cext_1257 B.$104.met1 PB.$10831.met4 0.00488968f
Cext_1258 B.$104.met1 PB.$10905.met4 0.00239096f
Cext_1259 B.$104.met1 VREF.$106.met2 0.00102047f
Cext_1260 B.$104.met1 sky130_gnd 0.028901f
Cext_1261 B.$105.met1 VREF.$106.met2 0.00102047f
Cext_1262 B.$105.met1 sky130_gnd 0.028901f
Cext_1263 B.$106.met1 PB.$10609.met4 0.00126111f
Cext_1264 B.$106.met1 VREF.$106.met2 0.00102047f
Cext_1265 B.$106.met1 sky130_gnd 0.028901f
Cext_1266 B.$107.met1 sky130_gnd 0.0797492f
Cext_1267 B.$108.met1 net2.$86.met1 0.00202952f
Cext_1268 B.$108.met1 sky130_gnd 0.0329687f
Cext_1269 B.$109.met1 sky130_gnd 0.0273716f
Cext_1270 B.$11.li1 sky130_gnd 0.0951158f
Cext_1271 B.$110.met1 sky130_gnd 0.0150491f
Cext_1272 B.$111.met1 sky130_gnd 0.0180206f
Cext_1273 B.$112.met1 net1.$622.met3 0.00163874f
Cext_1274 B.$112.met1 sky130_gnd 0.0286468f
Cext_1275 B.$113.met1 net1.$622.met3 0.0022685f
Cext_1276 B.$113.met1 sky130_gnd 0.0286468f
Cext_1277 B.$114.met1 net1.$591.met1 0.00272794f
Cext_1278 B.$114.met1 net1.$622.met3 0.00143676f
Cext_1279 B.$114.met1 sky130_gnd 0.0324673f
Cext_1280 B.$115.met2 VDD.$497.met2 0.00217266f
Cext_1281 B.$115.met2 VDD.$510.met3 0.00189063f
Cext_1282 B.$115.met2 sky130_gnd 0.0199089f
Cext_1283 B.$116.met2 VDD.$510.met3 0.00189063f
Cext_1284 B.$116.met2 VREF.$106.met2 0.00258732f
Cext_1285 B.$116.met2 sky130_gnd 0.013726f
Cext_1286 B.$118.met2 net1.$615.met2 0.00131918f
Cext_1287 B.$118.met2 net2.$90.met2 0.00117653f
Cext_1288 B.$118.met2 sky130_gnd 0.0216149f
Cext_1289 B.$119.met3 net1.$622.met3 0.175507f
Cext_1290 B.$119.met3 VDD.$510.met3 0.216363f
Cext_1291 B.$119.met3 VDD.$586.met4 0.00789773f
Cext_1292 B.$119.met3 VREF.$106.met2 0.0896837f
Cext_1293 B.$119.met3 VREF.$117.poly 0.00307129f
Cext_1294 B.$119.met3 VREF.$57.li1 0.0035382f
Cext_1295 B.$119.met3 VREF.$62.li1 0.00608786f
Cext_1296 B.$119.met3 VREF.$93.met1 0.00893719f
Cext_1297 B.$119.met3 VREF.$95.met1 0.00340424f
Cext_1298 B.$119.met3 VREF.$96.met1 0.00399385f
Cext_1299 B.$119.met3 VREF.$97.met1 0.00429678f
Cext_1300 B.$119.met3 VREF.$98.met1 0.00380673f
Cext_1301 B.$119.met3 VREF.$99.met1 0.0103555f
Cext_1302 B.$119.met3 VREF.P1.poly 0.00169192f
Cext_1303 B.$119.met3 sky130_gnd 0.779571f
Cext_1304 B.$12.li1 net1.$622.met3 0.00326453f
Cext_1305 B.$12.li1 net2.$92.met3 0.00217394f
Cext_1306 B.$12.li1 VDD.$510.met3 0.0057294f
Cext_1307 B.$12.li1 VDD.$511.met3 0.00583528f
Cext_1308 B.$12.li1 sky130_gnd 0.115912f
Cext_1309 B.$120.met3 net1.$622.met3 0.292039f
Cext_1310 B.$120.met3 net2.$37.li1 0.00559213f
Cext_1311 B.$120.met3 net2.$42.li1 0.00399689f
Cext_1312 B.$120.met3 net2.$80.met1 0.00995383f
Cext_1313 B.$120.met3 net2.$82.met1 0.00335184f
Cext_1314 B.$120.met3 net2.$83.met1 0.00382263f
Cext_1315 B.$120.met3 net2.$84.met1 0.00465596f
Cext_1316 B.$120.met3 net2.$85.met1 0.00409263f
Cext_1317 B.$120.met3 net2.$86.met1 0.00853606f
Cext_1318 B.$120.met3 net2.$90.met2 0.0790074f
Cext_1319 B.$120.met3 net2.$93.poly 0.00307129f
Cext_1320 B.$120.met3 net2.P0.poly 0.00179351f
Cext_1321 B.$120.met3 sky130_gnd 0.89309f
Cext_1322 B.$121.poly net1.$622.met3 0.00182725f
Cext_1323 B.$121.poly net2.$92.met3 0.00127511f
Cext_1324 B.$121.poly VDD.$510.met3 0.00222438f
Cext_1325 B.$121.poly VDD.$511.met3 0.00436796f
Cext_1326 B.$121.poly VREF.P1.poly 0.00116667f
Cext_1327 B.$121.poly sky130_gnd 0.352732f
Cext_1328 B.$122.poly sky130_gnd 0.17712f
Cext_1329 B.$123.poly sky130_gnd 0.17712f
Cext_1330 B.$124.poly sky130_gnd 0.344094f
Cext_1331 B.$125.poly net1.$623.poly 0.0014f
Cext_1332 B.$125.poly sky130_gnd 0.169993f
Cext_1333 B.$13.li1 VREF.$57.li1 0.00133022f
Cext_1334 B.$13.li1 sky130_gnd 0.0274479f
Cext_1335 B.$14.li1 sky130_gnd 0.0301038f
Cext_1336 B.$15.li1 sky130_gnd 0.0301038f
Cext_1337 B.$16.li1 sky130_gnd 0.0301038f
Cext_1338 B.$17.li1 sky130_gnd 0.0301038f
Cext_1339 B.$52.li1 sky130_gnd 0.0146524f
Cext_1340 B.$53.li1 net2.$42.li1 0.00175689f
Cext_1341 B.$53.li1 sky130_gnd 0.0400424f
Cext_1342 B.$54.li1 sky130_gnd 0.0293049f
Cext_1343 B.$55.li1 sky130_gnd 0.0219786f
Cext_1344 B.$56.li1 sky130_gnd 0.0219786f
Cext_1345 B.$57.li1 sky130_gnd 0.0293049f
Cext_1346 B.$58.li1 net1.$289.li1 0.00230932f
Cext_1347 B.$58.li1 sky130_gnd 0.0396983f
Cext_1348 B.P0.poly net2.P0.poly 0.00116667f
Cext_1349 B.P0.poly sky130_gnd 0.174903f
Cext_1350 B.P1.poly sky130_gnd 0.119207f
Cext_1351 BH PB.$11490.poly 0.0195921f
Cext_1352 BH PB.$5648.li1 0.0010623f
Cext_1353 BH PB.$5853.met1 0.00704515f
Cext_1354 BH PB.P3.poly 0.0140205f
Cext_1355 BH VDD.$480.met2 0.00273682f
Cext_1356 BH VDD.$501.met3 0.0018223f
Cext_1357 BH VDD.$502.met3 0.00129506f
Cext_1358 BH.$10.li1 sky130_gnd 0.0301038f
Cext_1359 BH.$100.li1 PB.$11490.poly 0.0181392f
Cext_1360 BH.$100.li1 VDD.$114.li1 0.0166571f
Cext_1361 BH.$100.li1 VDD.$72.li1 0.00107494f
Cext_1362 BH.$102.li1 PB.$11490.poly 0.0181392f
Cext_1363 BH.$102.li1 VDD.$115.li1 0.0168983f
Cext_1364 BH.$102.li1 VDD.$501.met3 0.00434984f
Cext_1365 BH.$102.li1 VDD.$74.li1 0.00107494f
Cext_1366 BH.$104.li1 PB.$11490.poly 0.0171523f
Cext_1367 BH.$104.li1 PB.P3.poly 0.00102285f
Cext_1368 BH.$104.li1 VDD.$116.li1 0.0166865f
Cext_1369 BH.$104.li1 VDD.$76.li1 0.00107494f
Cext_1370 BH.$106.li1 PB.$11490.poly 0.00177361f
Cext_1371 BH.$106.li1 PB.P3.poly 0.0164102f
Cext_1372 BH.$106.li1 VDD.$117.li1 0.0166794f
Cext_1373 BH.$106.li1 VDD.$78.li1 0.00107494f
Cext_1374 BH.$108.li1 PB.P3.poly 0.0178335f
Cext_1375 BH.$108.li1 VDD.$118.li1 0.0166794f
Cext_1376 BH.$108.li1 VDD.$80.li1 0.00107494f
Cext_1377 BH.$11.li1 sky130_gnd 0.0951158f
Cext_1378 BH.$110.li1 PB.P3.poly 0.0200476f
Cext_1379 BH.$110.li1 VDD.$119.li1 0.0166794f
Cext_1380 BH.$110.li1 VDD.$82.li1 0.00107494f
Cext_1381 BH.$112.li1 PB.P3.poly 0.0181838f
Cext_1382 BH.$112.li1 VDD.$120.li1 0.0166794f
Cext_1383 BH.$112.li1 VDD.$84.li1 0.00107494f
Cext_1384 BH.$114.li1 PB.P3.poly 0.0181838f
Cext_1385 BH.$114.li1 VDD.$121.li1 0.0166794f
Cext_1386 BH.$114.li1 VDD.$86.li1 0.00107494f
Cext_1387 BH.$116.li1 PB.P3.poly 0.0180851f
Cext_1388 BH.$116.li1 VDD.$122.li1 0.0152045f
Cext_1389 BH.$116.li1 VDD.$134.li1 0.0012197f
Cext_1390 BH.$116.li1 VDD.$88.li1 0.00107494f
Cext_1391 BH.$118.li1 PB.P3.poly 0.0180653f
Cext_1392 BH.$118.li1 VDD.$123.li1 0.0150925f
Cext_1393 BH.$118.li1 VDD.$134.li1 0.0012197f
Cext_1394 BH.$118.li1 VDD.$90.li1 0.00107494f
Cext_1395 BH.$12.li1 sky130_gnd 0.0188623f
Cext_1396 BH.$120.li1 PB.P3.poly 0.0181665f
Cext_1397 BH.$120.li1 VDD.$124.li1 0.0166652f
Cext_1398 BH.$120.li1 VDD.$92.li1 0.00107494f
Cext_1399 BH.$122.li1 PB.P3.poly 0.0181838f
Cext_1400 BH.$122.li1 VDD.$125.li1 0.0166794f
Cext_1401 BH.$122.li1 VDD.$94.li1 0.00107494f
Cext_1402 BH.$124.li1 PB.P3.poly 0.0181838f
Cext_1403 BH.$124.li1 VDD.$126.li1 0.0166794f
Cext_1404 BH.$124.li1 VDD.$96.li1 0.00107494f
Cext_1405 BH.$126.li1 PB.P3.poly 0.0178335f
Cext_1406 BH.$126.li1 VDD.$127.li1 0.0166794f
Cext_1407 BH.$126.li1 VDD.$98.li1 0.00107494f
Cext_1408 BH.$128.li1 PB.$11491.poly 0.00177361f
Cext_1409 BH.$128.li1 PB.P3.poly 0.0164102f
Cext_1410 BH.$128.li1 VDD.$100.li1 0.00107494f
Cext_1411 BH.$128.li1 VDD.$128.li1 0.0166794f
Cext_1412 BH.$130.li1 PB.$11491.poly 0.0171609f
Cext_1413 BH.$130.li1 PB.P3.poly 0.00102285f
Cext_1414 BH.$130.li1 VDD.$102.li1 0.00107494f
Cext_1415 BH.$130.li1 VDD.$129.li1 0.0166794f
Cext_1416 BH.$132.li1 PB.$11491.poly 0.0181838f
Cext_1417 BH.$132.li1 VDD.$104.li1 0.00107494f
Cext_1418 BH.$132.li1 VDD.$130.li1 0.0166794f
Cext_1419 BH.$134.li1 PB.$11491.poly 0.0187975f
Cext_1420 BH.$134.li1 VDD.$106.li1 0.00107494f
Cext_1421 BH.$134.li1 VDD.$131.li1 0.0166794f
Cext_1422 BH.$136.li1 PB.$11491.poly 0.0181838f
Cext_1423 BH.$136.li1 VDD.$108.li1 0.00107494f
Cext_1424 BH.$136.li1 VDD.$132.li1 0.0166794f
Cext_1425 BH.$138.li1 PB.$11491.poly 0.0176508f
Cext_1426 BH.$138.li1 VDD.$110.li1 0.00103015f
Cext_1427 BH.$138.li1 VDD.$133.li1 0.0158673f
Cext_1428 BH.$138.li1 VDD.$705.nwell 0.00236608f
Cext_1429 BH.$138.li1 sky130_gnd 0.00435263f
Cext_1430 BH.$14.li1 sky130_gnd 0.0187227f
Cext_1431 BH.$140.met1 sky130_gnd 0.107435f
Cext_1432 BH.$141.met1 sky130_gnd 0.028901f
Cext_1433 BH.$142.met1 sky130_gnd 0.028901f
Cext_1434 BH.$143.met1 sky130_gnd 0.028901f
Cext_1435 BH.$144.met1 sky130_gnd 0.028901f
Cext_1436 BH.$145.met1 sky130_gnd 0.028901f
Cext_1437 BH.$146.met1 sky130_gnd 0.028901f
Cext_1438 BH.$147.met1 sky130_gnd 0.0797492f
Cext_1439 BH.$148.met1 TAIL.$339.met3 0.00134089f
Cext_1440 BH.$148.met1 sky130_gnd 0.019591f
Cext_1441 BH.$149.met1 sky130_gnd 0.0200078f
Cext_1442 BH.$159.met1 sky130_gnd 0.0120458f
Cext_1443 BH.$16.li1 sky130_gnd 0.116764f
Cext_1444 BH.$161.met1 sky130_gnd 0.0207959f
Cext_1445 BH.$17.li1 sky130_gnd 0.0301038f
Cext_1446 BH.$170.met1 TAIL.$339.met3 0.00299307f
Cext_1447 BH.$170.met1 sky130_gnd 0.0118329f
Cext_1448 BH.$171.met1 sky130_gnd 0.0120458f
Cext_1449 BH.$18.li1 sky130_gnd 0.0301038f
Cext_1450 BH.$180.met1 TAIL.$339.met3 0.00296981f
Cext_1451 BH.$180.met1 sky130_gnd 0.0122477f
Cext_1452 BH.$181.met1 sky130_gnd 0.0120458f
Cext_1453 BH.$19.li1 sky130_gnd 0.0301038f
Cext_1454 BH.$190.met1 TAIL.$339.met3 0.00181447f
Cext_1455 BH.$190.met1 sky130_gnd 0.0122477f
Cext_1456 BH.$191.met1 sky130_gnd 0.0120458f
Cext_1457 BH.$20.li1 sky130_gnd 0.0301038f
Cext_1458 BH.$200.met1 TAIL.$339.met3 0.00145688f
Cext_1459 BH.$200.met1 sky130_gnd 0.0136603f
Cext_1460 BH.$201.met1 sky130_gnd 0.0120458f
Cext_1461 BH.$202.met1 TAIL.$339.met3 0.00166841f
Cext_1462 BH.$202.met1 sky130_gnd 0.0143234f
Cext_1463 BH.$203.met1 sky130_gnd 0.0120458f
Cext_1464 BH.$204.met1 TAIL.$339.met3 0.00173892f
Cext_1465 BH.$204.met1 sky130_gnd 0.0143234f
Cext_1466 BH.$205.met1 sky130_gnd 0.0120458f
Cext_1467 BH.$206.met1 TAIL.$339.met3 0.00145184f
Cext_1468 BH.$206.met1 sky130_gnd 0.0143234f
Cext_1469 BH.$207.met1 sky130_gnd 0.0120458f
Cext_1470 BH.$208.met1 TAIL.$339.met3 0.00152218f
Cext_1471 BH.$208.met1 sky130_gnd 0.0143234f
Cext_1472 BH.$209.met1 sky130_gnd 0.0120458f
Cext_1473 BH.$21.li1 sky130_gnd 0.0301038f
Cext_1474 BH.$210.met1 TAIL.$340.met3 0.00151718f
Cext_1475 BH.$210.met1 sky130_gnd 0.0200593f
Cext_1476 BH.$211.met1 sky130_gnd 0.0180031f
Cext_1477 BH.$212.met1 PB.$11490.poly 0.0184371f
Cext_1478 BH.$212.met1 PB.$5853.met1 0.00250407f
Cext_1479 BH.$212.met1 PB.P3.poly 0.00583088f
Cext_1480 BH.$212.met1 VDD.$370.met1 0.00150721f
Cext_1481 BH.$213.met1 PB.$11490.poly 0.00166075f
Cext_1482 BH.$213.met1 VDD.$112.li1 0.00553818f
Cext_1483 BH.$213.met1 VDD.$394.met1 0.00215361f
Cext_1484 BH.$213.met1 VDD.$684.nwell 0.00467529f
Cext_1485 BH.$213.met1 sky130_gnd 0.011845f
Cext_1486 BH.$214.met1 PB.$11490.poly 0.0130015f
Cext_1487 BH.$214.met1 VDD.$113.li1 0.00630018f
Cext_1488 BH.$214.met1 VDD.$371.met1 0.00158288f
Cext_1489 BH.$214.met1 VDD.$395.met1 0.00238554f
Cext_1490 BH.$214.met1 VDD.$685.nwell 0.00202126f
Cext_1491 BH.$214.met1 sky130_gnd 0.00649879f
Cext_1492 BH.$215.met1 PB.$11490.poly 0.0150995f
Cext_1493 BH.$215.met1 VDD.$114.li1 0.0064216f
Cext_1494 BH.$215.met1 VDD.$372.met1 0.00183333f
Cext_1495 BH.$215.met1 VDD.$396.met1 0.00238554f
Cext_1496 BH.$215.met1 VDD.$502.met3 0.00470383f
Cext_1497 BH.$215.met1 VDD.$686.nwell 0.00204366f
Cext_1498 BH.$215.met1 sky130_gnd 0.00649879f
Cext_1499 BH.$216.met1 PB.$11490.poly 0.0151301f
Cext_1500 BH.$216.met1 VDD.$115.li1 0.00639308f
Cext_1501 BH.$216.met1 VDD.$373.met1 0.00183333f
Cext_1502 BH.$216.met1 VDD.$397.met1 0.00238554f
Cext_1503 BH.$216.met1 VDD.$501.met3 0.00846577f
Cext_1504 BH.$216.met1 VDD.$502.met3 0.0107728f
Cext_1505 BH.$216.met1 VDD.$687.nwell 0.00211832f
Cext_1506 BH.$216.met1 sky130_gnd 0.00649879f
Cext_1507 BH.$217.met1 PB.$11490.poly 0.0141676f
Cext_1508 BH.$217.met1 VDD.$116.li1 0.00648749f
Cext_1509 BH.$217.met1 VDD.$374.met1 0.00183333f
Cext_1510 BH.$217.met1 VDD.$398.met1 0.00238554f
Cext_1511 BH.$217.met1 VDD.$502.met3 0.00163283f
Cext_1512 BH.$217.met1 VDD.$688.nwell 0.00204366f
Cext_1513 BH.$217.met1 sky130_gnd 0.00649879f
Cext_1514 BH.$218.met1 PB.P3.poly 0.0149101f
Cext_1515 BH.$218.met1 VDD.$117.li1 0.00658831f
Cext_1516 BH.$218.met1 VDD.$375.met1 0.00183333f
Cext_1517 BH.$218.met1 VDD.$399.met1 0.00238554f
Cext_1518 BH.$218.met1 VDD.$689.nwell 0.00211832f
Cext_1519 BH.$218.met1 sky130_gnd 0.00649879f
Cext_1520 BH.$219.met1 PB.P3.poly 0.0150866f
Cext_1521 BH.$219.met1 VDD.$118.li1 0.00658831f
Cext_1522 BH.$219.met1 VDD.$376.met1 0.00183333f
Cext_1523 BH.$219.met1 VDD.$400.met1 0.00238554f
Cext_1524 BH.$219.met1 VDD.$690.nwell 0.00211832f
Cext_1525 BH.$219.met1 sky130_gnd 0.00649879f
Cext_1526 BH.$220.met1 PB.P3.poly 0.0151301f
Cext_1527 BH.$220.met1 VDD.$119.li1 0.00658831f
Cext_1528 BH.$220.met1 VDD.$377.met1 0.00183333f
Cext_1529 BH.$220.met1 VDD.$401.met1 0.00238554f
Cext_1530 BH.$220.met1 VDD.$691.nwell 0.00211832f
Cext_1531 BH.$220.met1 sky130_gnd 0.00649879f
Cext_1532 BH.$221.met1 PB.P3.poly 0.0151301f
Cext_1533 BH.$221.met1 VDD.$120.li1 0.00702791f
Cext_1534 BH.$221.met1 VDD.$378.met1 0.00183333f
Cext_1535 BH.$221.met1 VDD.$402.met1 0.00238554f
Cext_1536 BH.$221.met1 VDD.$692.nwell 0.00167872f
Cext_1537 BH.$221.met1 sky130_gnd 0.00649879f
Cext_1538 BH.$222.met1 PB.P3.poly 0.0151301f
Cext_1539 BH.$222.met1 VDD.$121.li1 0.00712589f
Cext_1540 BH.$222.met1 VDD.$379.met1 0.00183333f
Cext_1541 BH.$222.met1 VDD.$403.met1 0.00238554f
Cext_1542 BH.$222.met1 VDD.$693.nwell 0.00158074f
Cext_1543 BH.$222.met1 sky130_gnd 0.00649879f
Cext_1544 BH.$223.met1 PB.P3.poly 0.0150079f
Cext_1545 BH.$223.met1 VDD.$122.li1 0.004119f
Cext_1546 BH.$223.met1 VDD.$134.li1 0.0034867f
Cext_1547 BH.$223.met1 VDD.$380.met1 0.00183333f
Cext_1548 BH.$223.met1 VDD.$392.met1 0.00424759f
Cext_1549 BH.$223.met1 VDD.$404.met1 0.0013253f
Cext_1550 BH.$223.met1 VDD.$481.met2 0.00559502f
Cext_1551 BH.$223.met1 sky130_gnd 0.00361044f
Cext_1552 BH.$224.met1 PB.P3.poly 0.0150323f
Cext_1553 BH.$224.met1 VDD.$123.li1 0.00423478f
Cext_1554 BH.$224.met1 VDD.$134.li1 0.0034867f
Cext_1555 BH.$224.met1 VDD.$381.met1 0.00183333f
Cext_1556 BH.$224.met1 VDD.$392.met1 0.00409302f
Cext_1557 BH.$224.met1 VDD.$405.met1 0.0013253f
Cext_1558 BH.$224.met1 VDD.$481.met2 0.0118489f
Cext_1559 BH.$224.met1 sky130_gnd 0.00361044f
Cext_1560 BH.$225.met1 PB.$5935.met3 0.0106962f
Cext_1561 BH.$225.met1 PB.P3.poly 0.0151369f
Cext_1562 BH.$225.met1 VDD.$124.li1 0.00639308f
Cext_1563 BH.$225.met1 VDD.$382.met1 0.00183333f
Cext_1564 BH.$225.met1 VDD.$406.met1 0.00238554f
Cext_1565 BH.$225.met1 VDD.$481.met2 0.00480896f
Cext_1566 BH.$225.met1 VDD.$502.met3 0.0142186f
Cext_1567 BH.$225.met1 VDD.$696.nwell 0.00158074f
Cext_1568 BH.$225.met1 sky130_gnd 0.00649879f
Cext_1569 BH.$226.met1 PB.P3.poly 0.0156397f
Cext_1570 BH.$226.met1 VDD.$125.li1 0.00691448f
Cext_1571 BH.$226.met1 VDD.$383.met1 0.00183333f
Cext_1572 BH.$226.met1 VDD.$407.met1 0.00238554f
Cext_1573 BH.$226.met1 VDD.$697.nwell 0.00167872f
Cext_1574 BH.$226.met1 sky130_gnd 0.00649879f
Cext_1575 BH.$227.met1 PB.P3.poly 0.0151413f
Cext_1576 BH.$227.met1 VDD.$126.li1 0.00647487f
Cext_1577 BH.$227.met1 VDD.$384.met1 0.00183333f
Cext_1578 BH.$227.met1 VDD.$408.met1 0.00238554f
Cext_1579 BH.$227.met1 VDD.$698.nwell 0.00211832f
Cext_1580 BH.$227.met1 sky130_gnd 0.00649879f
Cext_1581 BH.$228.met1 PB.P3.poly 0.0150979f
Cext_1582 BH.$228.met1 VDD.$127.li1 0.00647487f
Cext_1583 BH.$228.met1 VDD.$385.met1 0.00183333f
Cext_1584 BH.$228.met1 VDD.$409.met1 0.00238554f
Cext_1585 BH.$228.met1 VDD.$699.nwell 0.00211832f
Cext_1586 BH.$228.met1 sky130_gnd 0.00649879f
Cext_1587 BH.$229.met1 PB.P3.poly 0.0149214f
Cext_1588 BH.$229.met1 VDD.$128.li1 0.00647487f
Cext_1589 BH.$229.met1 VDD.$386.met1 0.00183333f
Cext_1590 BH.$229.met1 VDD.$410.met1 0.00238554f
Cext_1591 BH.$229.met1 VDD.$700.nwell 0.00211832f
Cext_1592 BH.$229.met1 sky130_gnd 0.00649879f
Cext_1593 BH.$230.met1 PB.$11491.poly 0.0142094f
Cext_1594 BH.$230.met1 VDD.$129.li1 0.00647487f
Cext_1595 BH.$230.met1 VDD.$387.met1 0.00183333f
Cext_1596 BH.$230.met1 VDD.$411.met1 0.00238554f
Cext_1597 BH.$230.met1 VDD.$701.nwell 0.00211832f
Cext_1598 BH.$230.met1 sky130_gnd 0.00649879f
Cext_1599 BH.$231.met1 PB.$11491.poly 0.0151413f
Cext_1600 BH.$231.met1 VDD.$130.li1 0.00647487f
Cext_1601 BH.$231.met1 VDD.$388.met1 0.00183333f
Cext_1602 BH.$231.met1 VDD.$412.met1 0.00238554f
Cext_1603 BH.$231.met1 VDD.$702.nwell 0.00211832f
Cext_1604 BH.$231.met1 sky130_gnd 0.00649879f
Cext_1605 BH.$232.met1 PB.$11491.poly 0.0151413f
Cext_1606 BH.$232.met1 VDD.$131.li1 0.00647487f
Cext_1607 BH.$232.met1 VDD.$389.met1 0.00183333f
Cext_1608 BH.$232.met1 VDD.$413.met1 0.00238554f
Cext_1609 BH.$232.met1 VDD.$703.nwell 0.00211832f
Cext_1610 BH.$232.met1 sky130_gnd 0.00649879f
Cext_1611 BH.$233.met1 PB.$11491.poly 0.0151413f
Cext_1612 BH.$233.met1 VDD.$132.li1 0.00647487f
Cext_1613 BH.$233.met1 VDD.$390.met1 0.00183333f
Cext_1614 BH.$233.met1 VDD.$414.met1 0.00238554f
Cext_1615 BH.$233.met1 VDD.$704.nwell 0.00211832f
Cext_1616 BH.$233.met1 sky130_gnd 0.00649879f
Cext_1617 BH.$234.met1 PB.$11491.poly 0.0146576f
Cext_1618 BH.$234.met1 VDD.$133.li1 0.00584537f
Cext_1619 BH.$234.met1 VDD.$391.met1 0.00165509f
Cext_1620 BH.$234.met1 VDD.$415.met1 0.00215361f
Cext_1621 BH.$234.met1 VDD.$705.nwell 0.00436503f
Cext_1622 BH.$234.met1 sky130_gnd 0.0124752f
Cext_1623 BH.$235.met2 TAIL.$220.met1 0.0024195f
Cext_1624 BH.$235.met2 TAIL.$339.met3 0.0147587f
Cext_1625 BH.$235.met2 sky130_gnd 0.244032f
Cext_1626 BH.$236.met2 N1.P0.nsdm 0.00173827f
Cext_1627 BH.$236.met2 PB.$11468.poly 0.0396592f
Cext_1628 BH.$236.met2 PB.$5476.li1 0.00600515f
Cext_1629 BH.$236.met2 PB.$5480.li1 0.00686295f
Cext_1630 BH.$236.met2 PB.$5764.met1 0.0260621f
Cext_1631 BH.$236.met2 PB.$5766.met1 0.0259995f
Cext_1632 BH.$236.met2 PB.$5776.met1 0.0165443f
Cext_1633 BH.$236.met2 PB.P0.poly 0.0163918f
Cext_1634 BH.$236.met2 TAIL.$250.met1 0.00597221f
Cext_1635 BH.$236.met2 TAIL.$251.met1 0.00682711f
Cext_1636 BH.$236.met2 TAIL.$252.met1 0.00682711f
Cext_1637 BH.$236.met2 TAIL.$253.met1 0.00682711f
Cext_1638 BH.$236.met2 TAIL.$254.met1 0.00682711f
Cext_1639 BH.$236.met2 TAIL.$255.met1 0.00682711f
Cext_1640 BH.$236.met2 TAIL.$256.met1 0.00682711f
Cext_1641 BH.$236.met2 TAIL.$257.met1 0.00682711f
Cext_1642 BH.$236.met2 TAIL.$258.met1 0.00682711f
Cext_1643 BH.$236.met2 TAIL.$259.met1 0.00682711f
Cext_1644 BH.$236.met2 TAIL.$260.met1 0.00682711f
Cext_1645 BH.$236.met2 TAIL.$261.met1 0.00682711f
Cext_1646 BH.$236.met2 TAIL.$262.met1 0.00682711f
Cext_1647 BH.$236.met2 TAIL.$263.met1 0.00682711f
Cext_1648 BH.$236.met2 TAIL.$264.met1 0.00616337f
Cext_1649 BH.$236.met2 TAIL.$58.li1 0.00118701f
Cext_1650 BH.$236.met2 TAIL.$60.li1 0.00135654f
Cext_1651 BH.$236.met2 TAIL.$62.li1 0.00135654f
Cext_1652 BH.$236.met2 TAIL.$64.li1 0.00135654f
Cext_1653 BH.$236.met2 TAIL.$66.li1 0.00135654f
Cext_1654 BH.$236.met2 TAIL.$68.li1 0.00135654f
Cext_1655 BH.$236.met2 TAIL.$70.li1 0.00135654f
Cext_1656 BH.$236.met2 TAIL.$72.li1 0.00135654f
Cext_1657 BH.$236.met2 TAIL.$74.li1 0.00135654f
Cext_1658 BH.$236.met2 TAIL.$76.li1 0.00135654f
Cext_1659 BH.$236.met2 TAIL.$78.li1 0.00135654f
Cext_1660 BH.$236.met2 TAIL.$80.li1 0.00135654f
Cext_1661 BH.$236.met2 TAIL.$82.li1 0.00135654f
Cext_1662 BH.$236.met2 TAIL.$84.li1 0.00135654f
Cext_1663 BH.$236.met2 TAIL.$86.li1 0.00122466f
Cext_1664 BH.$236.met2 TAIL.P1.nsdm 0.00491007f
Cext_1665 BH.$236.met2 VDD.$0.li1 0.00128178f
Cext_1666 BH.$236.met2 VDD.$345.met1 0.00616464f
Cext_1667 BH.$236.met2 VDD.$346.met1 0.00177639f
Cext_1668 BH.$236.met2 VDD.$477.met2 0.0201314f
Cext_1669 BH.$236.met2 VDD.$500.met3 0.00364459f
Cext_1670 BH.$236.met2 VDD.$662.nwell 0.0158371f
Cext_1671 BH.$236.met2 VDD.P3.nwell 0.00146714f
Cext_1672 BH.$236.met2 VSS.$220.met1 0.00575357f
Cext_1673 BH.$236.met2 VSS.$6.li1 0.00250391f
Cext_1674 BH.$236.met2 sky130_gnd 0.360308f
Cext_1675 BH.$237.met2 sky130_gnd 0.46221f
Cext_1676 BH.$238.met2 N1.$301.met2 0.00481687f
Cext_1677 BH.$238.met2 N1.$302.met2 0.00440544f
Cext_1678 BH.$238.met2 N1.P0.nsdm 0.00293704f
Cext_1679 BH.$238.met2 TAIL.$0.li1 0.00186285f
Cext_1680 BH.$238.met2 TAIL.$10.li1 0.00135654f
Cext_1681 BH.$238.met2 TAIL.$12.li1 0.00135654f
Cext_1682 BH.$238.met2 TAIL.$14.li1 0.00135654f
Cext_1683 BH.$238.met2 TAIL.$16.li1 0.00135654f
Cext_1684 BH.$238.met2 TAIL.$18.li1 0.00135654f
Cext_1685 BH.$238.met2 TAIL.$2.li1 0.0013377f
Cext_1686 BH.$238.met2 TAIL.$20.li1 0.00135654f
Cext_1687 BH.$238.met2 TAIL.$22.li1 0.00135654f
Cext_1688 BH.$238.met2 TAIL.$221.met1 0.00982184f
Cext_1689 BH.$238.met2 TAIL.$222.met1 0.00420682f
Cext_1690 BH.$238.met2 TAIL.$223.met1 0.00682711f
Cext_1691 BH.$238.met2 TAIL.$224.met1 0.00682711f
Cext_1692 BH.$238.met2 TAIL.$225.met1 0.00682711f
Cext_1693 BH.$238.met2 TAIL.$226.met1 0.00682711f
Cext_1694 BH.$238.met2 TAIL.$227.met1 0.00682711f
Cext_1695 BH.$238.met2 TAIL.$228.met1 0.00682711f
Cext_1696 BH.$238.met2 TAIL.$229.met1 0.00682711f
Cext_1697 BH.$238.met2 TAIL.$230.met1 0.00682711f
Cext_1698 BH.$238.met2 TAIL.$231.met1 0.00783564f
Cext_1699 BH.$238.met2 TAIL.$232.met1 0.00682711f
Cext_1700 BH.$238.met2 TAIL.$233.met1 0.00682711f
Cext_1701 BH.$238.met2 TAIL.$234.met1 0.00682711f
Cext_1702 BH.$238.met2 TAIL.$235.met1 0.00682711f
Cext_1703 BH.$238.met2 TAIL.$236.met1 0.00682711f
Cext_1704 BH.$238.met2 TAIL.$237.met1 0.00682711f
Cext_1705 BH.$238.met2 TAIL.$238.met1 0.00682711f
Cext_1706 BH.$238.met2 TAIL.$239.met1 0.00682711f
Cext_1707 BH.$238.met2 TAIL.$24.li1 0.00135654f
Cext_1708 BH.$238.met2 TAIL.$240.met1 0.00682711f
Cext_1709 BH.$238.met2 TAIL.$241.met1 0.00682711f
Cext_1710 BH.$238.met2 TAIL.$242.met1 0.00673011f
Cext_1711 BH.$238.met2 TAIL.$243.met1 0.00682711f
Cext_1712 BH.$238.met2 TAIL.$244.met1 0.00682711f
Cext_1713 BH.$238.met2 TAIL.$245.met1 0.00682711f
Cext_1714 BH.$238.met2 TAIL.$246.met1 0.00682711f
Cext_1715 BH.$238.met2 TAIL.$247.met1 0.00682711f
Cext_1716 BH.$238.met2 TAIL.$248.met1 0.00682711f
Cext_1717 BH.$238.met2 TAIL.$249.met1 0.00682711f
Cext_1718 BH.$238.met2 TAIL.$26.li1 0.00135654f
Cext_1719 BH.$238.met2 TAIL.$28.li1 0.00135654f
Cext_1720 BH.$238.met2 TAIL.$30.li1 0.00135654f
Cext_1721 BH.$238.met2 TAIL.$32.li1 0.00135654f
Cext_1722 BH.$238.met2 TAIL.$333.met2 0.00795356f
Cext_1723 BH.$238.met2 TAIL.$334.met2 0.0212844f
Cext_1724 BH.$238.met2 TAIL.$339.met3 0.102542f
Cext_1725 BH.$238.met2 TAIL.$34.li1 0.00135654f
Cext_1726 BH.$238.met2 TAIL.$36.li1 0.00135654f
Cext_1727 BH.$238.met2 TAIL.$38.li1 0.00135654f
Cext_1728 BH.$238.met2 TAIL.$4.li1 0.00135654f
Cext_1729 BH.$238.met2 TAIL.$40.li1 0.00135654f
Cext_1730 BH.$238.met2 TAIL.$42.li1 0.00126234f
Cext_1731 BH.$238.met2 TAIL.$44.li1 0.00130002f
Cext_1732 BH.$238.met2 TAIL.$46.li1 0.00135654f
Cext_1733 BH.$238.met2 TAIL.$48.li1 0.00135654f
Cext_1734 BH.$238.met2 TAIL.$50.li1 0.00135654f
Cext_1735 BH.$238.met2 TAIL.$52.li1 0.00135654f
Cext_1736 BH.$238.met2 TAIL.$54.li1 0.00135654f
Cext_1737 BH.$238.met2 TAIL.$56.li1 0.00135654f
Cext_1738 BH.$238.met2 TAIL.$6.li1 0.00135654f
Cext_1739 BH.$238.met2 TAIL.$8.li1 0.00135654f
Cext_1740 BH.$238.met2 TAIL.P1.nsdm 0.0104185f
Cext_1741 BH.$238.met2 VSS.$220.met1 0.00244101f
Cext_1742 BH.$238.met2 VSS.$366.met2 0.0118732f
Cext_1743 BH.$238.met2 VSS.$6.li1 0.00370152f
Cext_1744 BH.$238.met2 sky130_gnd 0.101801f
Cext_1745 BH.$24.li1 sky130_gnd 0.0125956f
Cext_1746 BH.$240.met2 PB.P3.poly 0.00258523f
Cext_1747 BH.$240.met2 VDD.$112.li1 0.00210899f
Cext_1748 BH.$240.met2 VDD.$482.met2 0.003125f
Cext_1749 BH.$240.met2 VDD.$502.met3 0.00509049f
Cext_1750 BH.$240.met2 VDD.$684.nwell 0.0032509f
Cext_1751 BH.$240.met2 sky130_gnd 0.0124794f
Cext_1752 BH.$241.met3 PB.$11468.poly 0.0766014f
Cext_1753 BH.$241.met3 PB.$5766.met1 0.00166408f
Cext_1754 BH.$241.met3 PB.$5768.met1 0.00544181f
Cext_1755 BH.$241.met3 PB.$5770.met1 0.0058368f
Cext_1756 BH.$241.met3 PB.$5772.met1 0.00567379f
Cext_1757 BH.$241.met3 PB.$5774.met1 0.0054857f
Cext_1758 BH.$241.met3 PB.$5776.met1 0.00415256f
Cext_1759 BH.$241.met3 PB.$5778.met1 0.00557347f
Cext_1760 BH.$241.met3 PB.$5780.met1 0.00558601f
Cext_1761 BH.$241.met3 PB.$5783.met1 0.00589322f
Cext_1762 BH.$241.met3 PB.$5785.met1 0.00407377f
Cext_1763 BH.$241.met3 VDD.$0.li1 0.00293661f
Cext_1764 BH.$241.met3 VDD.$2.li1 0.00102884f
Cext_1765 BH.$241.met3 VDD.$345.met1 0.00512107f
Cext_1766 BH.$241.met3 VDD.$346.met1 0.00239057f
Cext_1767 BH.$241.met3 VDD.$46.li1 0.00245247f
Cext_1768 BH.$241.met3 VDD.$477.met2 0.0154158f
Cext_1769 BH.$241.met3 VDD.$500.met3 0.128654f
Cext_1770 BH.$241.met3 VDD.$501.met3 0.0976389f
Cext_1771 BH.$241.met3 VDD.$662.nwell 0.00671022f
Cext_1772 BH.$241.met3 VDD.$664.nwell 0.00167037f
Cext_1773 BH.$241.met3 VSS.$220.met1 0.0017458f
Cext_1774 BH.$241.met3 sky130_gnd 0.0720237f
Cext_1775 BH.$242.met3 PB.$11490.poly 0.0916521f
Cext_1776 BH.$242.met3 PB.$11512.poly 0.00499484f
Cext_1777 BH.$242.met3 PB.$5787.met1 0.00334132f
Cext_1778 BH.$242.met3 PB.$5789.met1 0.00394567f
Cext_1779 BH.$242.met3 PB.$5792.met1 0.0040836f
Cext_1780 BH.$242.met3 PB.$5794.met1 0.00370115f
Cext_1781 BH.$242.met3 PB.$5796.met1 0.00404598f
Cext_1782 BH.$242.met3 PB.$5798.met1 0.00398328f
Cext_1783 BH.$242.met3 PB.$5800.met1 0.00370115f
Cext_1784 BH.$242.met3 PB.$5802.met1 0.00414629f
Cext_1785 BH.$242.met3 PB.$5804.met1 0.00388297f
Cext_1786 BH.$242.met3 PB.$5806.met1 0.0036063f
Cext_1787 BH.$242.met3 PB.$5853.met1 0.00200778f
Cext_1788 BH.$242.met3 VDD.$112.li1 0.00135f
Cext_1789 BH.$242.met3 VDD.$369.met1 0.00241993f
Cext_1790 BH.$242.met3 VDD.$370.met1 0.00716653f
Cext_1791 BH.$242.met3 VDD.$371.met1 0.00350052f
Cext_1792 BH.$242.met3 VDD.$479.met2 0.0143196f
Cext_1793 BH.$242.met3 VDD.$480.met2 0.0448246f
Cext_1794 BH.$242.met3 VDD.$501.met3 0.220225f
Cext_1795 BH.$242.met3 VDD.$502.met3 0.0102778f
Cext_1796 BH.$242.met3 VDD.$662.nwell 0.00485638f
Cext_1797 BH.$242.met3 VDD.$664.nwell 0.00105019f
Cext_1798 BH.$242.met3 VDD.$68.li1 0.00437462f
Cext_1799 BH.$242.met3 VDD.$684.nwell 0.00167402f
Cext_1800 BH.$242.met3 VDD.$70.li1 0.00162849f
Cext_1801 BH.$242.met3 VSS.$13.li1 0.00297556f
Cext_1802 BH.$242.met3 sky130_gnd 0.0601982f
Cext_1803 BH.$243.poly sky130_gnd 0.354459f
Cext_1804 BH.$244.poly sky130_gnd 0.17712f
Cext_1805 BH.$245.poly sky130_gnd 0.17712f
Cext_1806 BH.$246.poly sky130_gnd 0.344094f
Cext_1807 BH.$247.poly N1.$0.li1 0.0174209f
Cext_1808 BH.$247.poly N1.$10.li1 0.0183522f
Cext_1809 BH.$247.poly N1.$12.li1 0.0183522f
Cext_1810 BH.$247.poly N1.$14.li1 0.0183522f
Cext_1811 BH.$247.poly N1.$16.li1 0.0183522f
Cext_1812 BH.$247.poly N1.$18.li1 0.0183522f
Cext_1813 BH.$247.poly N1.$198.met1 0.0134851f
Cext_1814 BH.$247.poly N1.$199.met1 0.0151107f
Cext_1815 BH.$247.poly N1.$2.li1 0.0182832f
Cext_1816 BH.$247.poly N1.$20.li1 0.00802436f
Cext_1817 BH.$247.poly N1.$200.met1 0.0153758f
Cext_1818 BH.$247.poly N1.$201.met1 0.0153421f
Cext_1819 BH.$247.poly N1.$202.met1 0.0153421f
Cext_1820 BH.$247.poly N1.$203.met1 0.0153891f
Cext_1821 BH.$247.poly N1.$204.met1 0.0153891f
Cext_1822 BH.$247.poly N1.$205.met1 0.0153891f
Cext_1823 BH.$247.poly N1.$206.met1 0.0153891f
Cext_1824 BH.$247.poly N1.$207.met1 0.0153891f
Cext_1825 BH.$247.poly N1.$208.met1 0.00591478f
Cext_1826 BH.$247.poly N1.$301.met2 0.02194f
Cext_1827 BH.$247.poly N1.$302.met2 0.0192947f
Cext_1828 BH.$247.poly N1.$308.met3 0.0161011f
Cext_1829 BH.$247.poly N1.$4.li1 0.0183463f
Cext_1830 BH.$247.poly N1.$6.li1 0.0183522f
Cext_1831 BH.$247.poly N1.$8.li1 0.0183522f
Cext_1832 BH.$247.poly TAIL.$0.li1 0.0174642f
Cext_1833 BH.$247.poly TAIL.$10.li1 0.0181392f
Cext_1834 BH.$247.poly TAIL.$12.li1 0.0181392f
Cext_1835 BH.$247.poly TAIL.$14.li1 0.0181392f
Cext_1836 BH.$247.poly TAIL.$16.li1 0.0181392f
Cext_1837 BH.$247.poly TAIL.$18.li1 0.0181392f
Cext_1838 BH.$247.poly TAIL.$2.li1 0.0181146f
Cext_1839 BH.$247.poly TAIL.$20.li1 0.00802436f
Cext_1840 BH.$247.poly TAIL.$221.met1 0.0134714f
Cext_1841 BH.$247.poly TAIL.$222.met1 0.0149992f
Cext_1842 BH.$247.poly TAIL.$223.met1 0.0151239f
Cext_1843 BH.$247.poly TAIL.$224.met1 0.0151301f
Cext_1844 BH.$247.poly TAIL.$225.met1 0.0151301f
Cext_1845 BH.$247.poly TAIL.$226.met1 0.0151301f
Cext_1846 BH.$247.poly TAIL.$227.met1 0.0151301f
Cext_1847 BH.$247.poly TAIL.$228.met1 0.0151301f
Cext_1848 BH.$247.poly TAIL.$229.met1 0.0151301f
Cext_1849 BH.$247.poly TAIL.$230.met1 0.0151301f
Cext_1850 BH.$247.poly TAIL.$231.met1 0.00591478f
Cext_1851 BH.$247.poly TAIL.$334.met2 0.00225299f
Cext_1852 BH.$247.poly TAIL.$339.met3 0.0494794f
Cext_1853 BH.$247.poly TAIL.$340.met3 0.00748613f
Cext_1854 BH.$247.poly TAIL.$4.li1 0.0181392f
Cext_1855 BH.$247.poly TAIL.$6.li1 0.0181392f
Cext_1856 BH.$247.poly TAIL.$8.li1 0.0181392f
Cext_1857 BH.$247.poly VSS.$6.li1 0.0105923f
Cext_1858 BH.$247.poly sky130_gnd 0.500174f
Cext_1859 BH.$248.poly N1.$231.met1 0.00591478f
Cext_1860 BH.$248.poly N1.$232.met1 0.0153891f
Cext_1861 BH.$248.poly N1.$233.met1 0.0153891f
Cext_1862 BH.$248.poly N1.$234.met1 0.0153891f
Cext_1863 BH.$248.poly N1.$235.met1 0.0153891f
Cext_1864 BH.$248.poly N1.$236.met1 0.0153891f
Cext_1865 BH.$248.poly N1.$237.met1 0.0153891f
Cext_1866 BH.$248.poly N1.$238.met1 0.0157962f
Cext_1867 BH.$248.poly N1.$239.met1 0.0153891f
Cext_1868 BH.$248.poly N1.$240.met1 0.0153891f
Cext_1869 BH.$248.poly N1.$241.met1 0.0138929f
Cext_1870 BH.$248.poly N1.$66.li1 0.00802436f
Cext_1871 BH.$248.poly N1.$68.li1 0.0184308f
Cext_1872 BH.$248.poly N1.$70.li1 0.0183522f
Cext_1873 BH.$248.poly N1.$72.li1 0.0183522f
Cext_1874 BH.$248.poly N1.$74.li1 0.0183522f
Cext_1875 BH.$248.poly N1.$76.li1 0.0183522f
Cext_1876 BH.$248.poly N1.$78.li1 0.0183522f
Cext_1877 BH.$248.poly N1.$80.li1 0.0183522f
Cext_1878 BH.$248.poly N1.$82.li1 0.0183522f
Cext_1879 BH.$248.poly N1.$84.li1 0.0183522f
Cext_1880 BH.$248.poly N1.$86.li1 0.0174771f
Cext_1881 BH.$248.poly PB.$11468.poly 0.00790461f
Cext_1882 BH.$248.poly TAIL.$254.met1 0.00591478f
Cext_1883 BH.$248.poly TAIL.$255.met1 0.0151301f
Cext_1884 BH.$248.poly TAIL.$256.met1 0.0151301f
Cext_1885 BH.$248.poly TAIL.$257.met1 0.0151301f
Cext_1886 BH.$248.poly TAIL.$258.met1 0.0151301f
Cext_1887 BH.$248.poly TAIL.$259.met1 0.0151301f
Cext_1888 BH.$248.poly TAIL.$260.met1 0.0151301f
Cext_1889 BH.$248.poly TAIL.$261.met1 0.0151301f
Cext_1890 BH.$248.poly TAIL.$262.met1 0.0151301f
Cext_1891 BH.$248.poly TAIL.$263.met1 0.0151301f
Cext_1892 BH.$248.poly TAIL.$264.met1 0.0136591f
Cext_1893 BH.$248.poly TAIL.$66.li1 0.00802436f
Cext_1894 BH.$248.poly TAIL.$68.li1 0.0190764f
Cext_1895 BH.$248.poly TAIL.$70.li1 0.0181392f
Cext_1896 BH.$248.poly TAIL.$72.li1 0.0181392f
Cext_1897 BH.$248.poly TAIL.$74.li1 0.0181392f
Cext_1898 BH.$248.poly TAIL.$76.li1 0.0181392f
Cext_1899 BH.$248.poly TAIL.$78.li1 0.0181392f
Cext_1900 BH.$248.poly TAIL.$80.li1 0.0181392f
Cext_1901 BH.$248.poly TAIL.$82.li1 0.0181392f
Cext_1902 BH.$248.poly TAIL.$84.li1 0.0181392f
Cext_1903 BH.$248.poly TAIL.$86.li1 0.0172849f
Cext_1904 BH.$248.poly VDD.$500.met3 0.0010607f
Cext_1905 BH.$248.poly VSS.$6.li1 0.0107009f
Cext_1906 BH.$248.poly sky130_gnd 0.494555f
Cext_1907 BH.$26.li1 sky130_gnd 0.0124499f
Cext_1908 BH.$36.li1 sky130_gnd 0.0125956f
Cext_1909 BH.$38.li1 sky130_gnd 0.0124499f
Cext_1910 BH.$48.li1 sky130_gnd 0.0125956f
Cext_1911 BH.$50.li1 sky130_gnd 0.0124499f
Cext_1912 BH.$60.li1 sky130_gnd 0.0125956f
Cext_1913 BH.$62.li1 sky130_gnd 0.0124499f
Cext_1914 BH.$72.li1 sky130_gnd 0.0135754f
Cext_1915 BH.$74.li1 sky130_gnd 0.0124499f
Cext_1916 BH.$76.li1 sky130_gnd 0.0140353f
Cext_1917 BH.$78.li1 sky130_gnd 0.0124499f
Cext_1918 BH.$80.li1 sky130_gnd 0.0140353f
Cext_1919 BH.$82.li1 sky130_gnd 0.0124499f
Cext_1920 BH.$84.li1 sky130_gnd 0.0140353f
Cext_1921 BH.$86.li1 sky130_gnd 0.0124499f
Cext_1922 BH.$88.li1 sky130_gnd 0.0140353f
Cext_1923 BH.$90.li1 sky130_gnd 0.0124499f
Cext_1924 BH.$92.li1 sky130_gnd 0.0191686f
Cext_1925 BH.$94.li1 sky130_gnd 0.0176493f
Cext_1926 BH.$96.li1 PB.$11490.poly 0.0172849f
Cext_1927 BH.$96.li1 VDD.$112.li1 0.0157492f
Cext_1928 BH.$96.li1 VDD.$68.li1 0.00103015f
Cext_1929 BH.$96.li1 VDD.$684.nwell 0.00236608f
Cext_1930 BH.$96.li1 sky130_gnd 0.00394985f
Cext_1931 BH.$98.li1 PB.$11490.poly 0.0181392f
Cext_1932 BH.$98.li1 VDD.$113.li1 0.017145f
Cext_1933 BH.$98.li1 VDD.$70.li1 0.00107494f
Cext_1934 BH.P0.poly N1.$20.li1 0.0103278f
Cext_1935 BH.P0.poly N1.$208.met1 0.00947428f
Cext_1936 BH.P0.poly N1.$209.met1 0.0153804f
Cext_1937 BH.P0.poly N1.$210.met1 0.0153891f
Cext_1938 BH.P0.poly N1.$211.met1 0.0153891f
Cext_1939 BH.P0.poly N1.$212.met1 0.0153891f
Cext_1940 BH.P0.poly N1.$213.met1 0.0153891f
Cext_1941 BH.P0.poly N1.$214.met1 0.0153891f
Cext_1942 BH.P0.poly N1.$215.met1 0.0153891f
Cext_1943 BH.P0.poly N1.$216.met1 0.0153891f
Cext_1944 BH.P0.poly N1.$217.met1 0.0153891f
Cext_1945 BH.P0.poly N1.$218.met1 0.0153421f
Cext_1946 BH.P0.poly N1.$219.met1 0.0151637f
Cext_1947 BH.P0.poly N1.$22.li1 0.0182822f
Cext_1948 BH.P0.poly N1.$220.met1 0.0152012f
Cext_1949 BH.P0.poly N1.$221.met1 0.0153891f
Cext_1950 BH.P0.poly N1.$222.met1 0.0153891f
Cext_1951 BH.P0.poly N1.$223.met1 0.0153891f
Cext_1952 BH.P0.poly N1.$224.met1 0.0153891f
Cext_1953 BH.P0.poly N1.$225.met1 0.0153891f
Cext_1954 BH.P0.poly N1.$226.met1 0.0153891f
Cext_1955 BH.P0.poly N1.$227.met1 0.0153891f
Cext_1956 BH.P0.poly N1.$228.met1 0.0153891f
Cext_1957 BH.P0.poly N1.$229.met1 0.0153891f
Cext_1958 BH.P0.poly N1.$230.met1 0.0153804f
Cext_1959 BH.P0.poly N1.$231.met1 0.00947428f
Cext_1960 BH.P0.poly N1.$24.li1 0.0183522f
Cext_1961 BH.P0.poly N1.$26.li1 0.0183522f
Cext_1962 BH.P0.poly N1.$28.li1 0.0183522f
Cext_1963 BH.P0.poly N1.$30.li1 0.0183522f
Cext_1964 BH.P0.poly N1.$32.li1 0.0183522f
Cext_1965 BH.P0.poly N1.$34.li1 0.0183522f
Cext_1966 BH.P0.poly N1.$36.li1 0.0183522f
Cext_1967 BH.P0.poly N1.$38.li1 0.0183522f
Cext_1968 BH.P0.poly N1.$40.li1 0.0183522f
Cext_1969 BH.P0.poly N1.$42.li1 0.018229f
Cext_1970 BH.P0.poly N1.$44.li1 0.0182783f
Cext_1971 BH.P0.poly N1.$46.li1 0.0183522f
Cext_1972 BH.P0.poly N1.$48.li1 0.0183522f
Cext_1973 BH.P0.poly N1.$50.li1 0.0183522f
Cext_1974 BH.P0.poly N1.$52.li1 0.0183522f
Cext_1975 BH.P0.poly N1.$54.li1 0.0183522f
Cext_1976 BH.P0.poly N1.$56.li1 0.0183522f
Cext_1977 BH.P0.poly N1.$58.li1 0.0183522f
Cext_1978 BH.P0.poly N1.$60.li1 0.0183522f
Cext_1979 BH.P0.poly N1.$62.li1 0.0183522f
Cext_1980 BH.P0.poly N1.$64.li1 0.0182822f
Cext_1981 BH.P0.poly N1.$66.li1 0.0103278f
Cext_1982 BH.P0.poly TAIL.$20.li1 0.0101148f
Cext_1983 BH.P0.poly TAIL.$22.li1 0.0180692f
Cext_1984 BH.P0.poly TAIL.$231.met1 0.00921527f
Cext_1985 BH.P0.poly TAIL.$232.met1 0.0151214f
Cext_1986 BH.P0.poly TAIL.$233.met1 0.0151301f
Cext_1987 BH.P0.poly TAIL.$234.met1 0.0151301f
Cext_1988 BH.P0.poly TAIL.$235.met1 0.0151301f
Cext_1989 BH.P0.poly TAIL.$236.met1 0.0151301f
Cext_1990 BH.P0.poly TAIL.$237.met1 0.0151301f
Cext_1991 BH.P0.poly TAIL.$238.met1 0.0151301f
Cext_1992 BH.P0.poly TAIL.$239.met1 0.0151301f
Cext_1993 BH.P0.poly TAIL.$24.li1 0.0181392f
Cext_1994 BH.P0.poly TAIL.$240.met1 0.0151301f
Cext_1995 BH.P0.poly TAIL.$241.met1 0.0151301f
Cext_1996 BH.P0.poly TAIL.$242.met1 0.0151301f
Cext_1997 BH.P0.poly TAIL.$243.met1 0.0151301f
Cext_1998 BH.P0.poly TAIL.$244.met1 0.0151301f
Cext_1999 BH.P0.poly TAIL.$245.met1 0.0151301f
Cext_2000 BH.P0.poly TAIL.$246.met1 0.0151301f
Cext_2001 BH.P0.poly TAIL.$247.met1 0.0151301f
Cext_2002 BH.P0.poly TAIL.$248.met1 0.0151301f
Cext_2003 BH.P0.poly TAIL.$249.met1 0.0151301f
Cext_2004 BH.P0.poly TAIL.$250.met1 0.0151301f
Cext_2005 BH.P0.poly TAIL.$251.met1 0.0151301f
Cext_2006 BH.P0.poly TAIL.$252.met1 0.0151301f
Cext_2007 BH.P0.poly TAIL.$253.met1 0.0151214f
Cext_2008 BH.P0.poly TAIL.$254.met1 0.00921527f
Cext_2009 BH.P0.poly TAIL.$26.li1 0.0181392f
Cext_2010 BH.P0.poly TAIL.$28.li1 0.0181392f
Cext_2011 BH.P0.poly TAIL.$30.li1 0.0181392f
Cext_2012 BH.P0.poly TAIL.$32.li1 0.0181392f
Cext_2013 BH.P0.poly TAIL.$339.met3 0.146628f
Cext_2014 BH.P0.poly TAIL.$34.li1 0.0181392f
Cext_2015 BH.P0.poly TAIL.$340.met3 0.0194832f
Cext_2016 BH.P0.poly TAIL.$36.li1 0.0181392f
Cext_2017 BH.P0.poly TAIL.$38.li1 0.0181392f
Cext_2018 BH.P0.poly TAIL.$40.li1 0.0181392f
Cext_2019 BH.P0.poly TAIL.$42.li1 0.0181392f
Cext_2020 BH.P0.poly TAIL.$44.li1 0.0181392f
Cext_2021 BH.P0.poly TAIL.$46.li1 0.0181392f
Cext_2022 BH.P0.poly TAIL.$48.li1 0.0181392f
Cext_2023 BH.P0.poly TAIL.$50.li1 0.0181392f
Cext_2024 BH.P0.poly TAIL.$52.li1 0.0181392f
Cext_2025 BH.P0.poly TAIL.$54.li1 0.0181392f
Cext_2026 BH.P0.poly TAIL.$56.li1 0.0181392f
Cext_2027 BH.P0.poly TAIL.$58.li1 0.0181392f
Cext_2028 BH.P0.poly TAIL.$60.li1 0.0181392f
Cext_2029 BH.P0.poly TAIL.$62.li1 0.0181392f
Cext_2030 BH.P0.poly TAIL.$64.li1 0.0180692f
Cext_2031 BH.P0.poly TAIL.$66.li1 0.0101148f
Cext_2032 BH.P0.poly VSS.$366.met2 0.0232399f
Cext_2033 BH.P0.poly VSS.$415.met3 0.0161011f
Cext_2034 BH.P0.poly VSS.$6.li1 0.0235013f
Cext_2035 BH.P0.psdm PB.$5935.met3 0.00270184f
Cext_2036 BH.P0.psdm VDD.$502.met3 0.00635946f
Cext_2037 BH.P1.poly sky130_gnd 0.119207f
Cext_2038 N1 TAIL.$340.met3 0.0429706f
Cext_2039 N1 VSS.$366.met2 0.00353864f
Cext_2040 N1 VSS.$6.li1 0.00682342f
Cext_2041 N1 sky130_gnd 0.0122508f
Cext_2042 N1.$0.li1 TAIL.$0.li1 0.00103015f
Cext_2043 N1.$0.li1 TAIL.$339.met3 0.00101143f
Cext_2044 N1.$0.li1 VSS.$366.met2 0.00149174f
Cext_2045 N1.$0.li1 VSS.$6.li1 0.01275f
Cext_2046 N1.$0.li1 sky130_gnd 0.00657328f
Cext_2047 N1.$10.li1 TAIL.$10.li1 0.00111142f
Cext_2048 N1.$10.li1 VSS.$366.met2 0.00165239f
Cext_2049 N1.$10.li1 VSS.$6.li1 0.0133043f
Cext_2050 N1.$100.li1 VDD.P1.nwell 0.00144114f
Cext_2051 N1.$100.li1 sky130_gnd 0.0125941f
Cext_2052 N1.$102.li1 VDD.P1.nwell 0.00144114f
Cext_2053 N1.$102.li1 sky130_gnd 0.0125941f
Cext_2054 N1.$104.li1 VDD.P1.nwell 0.00144114f
Cext_2055 N1.$104.li1 sky130_gnd 0.0125941f
Cext_2056 N1.$106.li1 VDD.P1.nwell 0.00144114f
Cext_2057 N1.$106.li1 sky130_gnd 0.0125941f
Cext_2058 N1.$108.li1 sky130_gnd 0.0125941f
Cext_2059 N1.$110.li1 sky130_gnd 0.0125941f
Cext_2060 N1.$112.li1 VDD.$750.nwell 0.00144114f
Cext_2061 N1.$112.li1 sky130_gnd 0.0125941f
Cext_2062 N1.$114.li1 VDD.$750.nwell 0.00144114f
Cext_2063 N1.$114.li1 sky130_gnd 0.0125941f
Cext_2064 N1.$116.li1 VDD.$750.nwell 0.00144114f
Cext_2065 N1.$116.li1 sky130_gnd 0.0125941f
Cext_2066 N1.$118.li1 VDD.$750.nwell 0.00144114f
Cext_2067 N1.$118.li1 sky130_gnd 0.0125941f
Cext_2068 N1.$12.li1 TAIL.$12.li1 0.00111142f
Cext_2069 N1.$12.li1 VSS.$366.met2 0.00165239f
Cext_2070 N1.$12.li1 VSS.$6.li1 0.0133043f
Cext_2071 N1.$120.li1 VDD.$750.nwell 0.00144114f
Cext_2072 N1.$120.li1 sky130_gnd 0.0125941f
Cext_2073 N1.$122.li1 VDD.$750.nwell 0.00144114f
Cext_2074 N1.$122.li1 sky130_gnd 0.0125941f
Cext_2075 N1.$124.li1 VDD.$750.nwell 0.00144114f
Cext_2076 N1.$124.li1 sky130_gnd 0.0125941f
Cext_2077 N1.$126.li1 VDD.$750.nwell 0.00144114f
Cext_2078 N1.$126.li1 sky130_gnd 0.0125941f
Cext_2079 N1.$128.li1 VDD.$750.nwell 0.00469712f
Cext_2080 N1.$128.li1 sky130_gnd 0.0145347f
Cext_2081 N1.$130.li1 VDD.$750.nwell 0.00469712f
Cext_2082 N1.$130.li1 sky130_gnd 0.0145347f
Cext_2083 N1.$132.li1 VDD.$272.li1 0.00103015f
Cext_2084 N1.$132.li1 VDD.$294.li1 0.0156428f
Cext_2085 N1.$132.li1 VDD.$750.nwell 0.00238369f
Cext_2086 N1.$132.li1 sky130_gnd 0.00440788f
Cext_2087 N1.$134.li1 VDD.$274.li1 0.00107494f
Cext_2088 N1.$134.li1 VDD.$295.li1 0.01638f
Cext_2089 N1.$136.li1 VDD.$276.li1 0.00107494f
Cext_2090 N1.$136.li1 VDD.$296.li1 0.0166429f
Cext_2091 N1.$138.li1 VDD.$278.li1 0.00107494f
Cext_2092 N1.$138.li1 VDD.$297.li1 0.0166429f
Cext_2093 N1.$138.li1 VDD.$504.met3 0.00356449f
Cext_2094 N1.$14.li1 TAIL.$14.li1 0.00111142f
Cext_2095 N1.$14.li1 VSS.$366.met2 0.00165239f
Cext_2096 N1.$14.li1 VSS.$6.li1 0.0133043f
Cext_2097 N1.$140.li1 VDD.$280.li1 0.00107494f
Cext_2098 N1.$140.li1 VDD.$298.li1 0.0166429f
Cext_2099 N1.$142.li1 VDD.$282.li1 0.00107494f
Cext_2100 N1.$142.li1 VDD.$299.li1 0.0165341f
Cext_2101 N1.$144.li1 VDD.$284.li1 0.00107494f
Cext_2102 N1.$144.li1 VDD.$300.li1 0.016647f
Cext_2103 N1.$146.li1 VDD.$286.li1 0.00107494f
Cext_2104 N1.$146.li1 VDD.$301.li1 0.0166794f
Cext_2105 N1.$148.li1 VDD.$288.li1 0.00107494f
Cext_2106 N1.$148.li1 VDD.$302.li1 0.0166794f
Cext_2107 N1.$150.li1 VDD.$290.li1 0.00107494f
Cext_2108 N1.$150.li1 VDD.$303.li1 0.0166794f
Cext_2109 N1.$152.li1 VDD.$292.li1 0.00103015f
Cext_2110 N1.$152.li1 VDD.$304.li1 0.0157355f
Cext_2111 N1.$152.li1 VDD.$750.nwell 0.00238369f
Cext_2112 N1.$152.li1 sky130_gnd 0.00440788f
Cext_2113 N1.$154.li1 VDD.$750.nwell 0.00263318f
Cext_2114 N1.$154.li1 VDD.P2.nwell 0.00129811f
Cext_2115 N1.$154.li1 sky130_gnd 0.0153005f
Cext_2116 N1.$156.li1 VDD.$750.nwell 0.00263318f
Cext_2117 N1.$156.li1 VDD.P2.nwell 0.00129811f
Cext_2118 N1.$156.li1 sky130_gnd 0.0153005f
Cext_2119 N1.$158.li1 VDD.P2.nwell 0.00144114f
Cext_2120 N1.$158.li1 sky130_gnd 0.0125941f
Cext_2121 N1.$16.li1 TAIL.$16.li1 0.00111142f
Cext_2122 N1.$16.li1 VSS.$366.met2 0.00165239f
Cext_2123 N1.$16.li1 VSS.$6.li1 0.0133043f
Cext_2124 N1.$160.li1 VDD.P2.nwell 0.00144114f
Cext_2125 N1.$160.li1 sky130_gnd 0.0125941f
Cext_2126 N1.$162.li1 VDD.P2.nwell 0.00144114f
Cext_2127 N1.$162.li1 sky130_gnd 0.0125941f
Cext_2128 N1.$164.li1 VDD.P2.nwell 0.00144114f
Cext_2129 N1.$164.li1 sky130_gnd 0.0125941f
Cext_2130 N1.$166.li1 VDD.P2.nwell 0.00144114f
Cext_2131 N1.$166.li1 sky130_gnd 0.0125941f
Cext_2132 N1.$168.li1 VDD.P2.nwell 0.00144114f
Cext_2133 N1.$168.li1 sky130_gnd 0.0125941f
Cext_2134 N1.$170.li1 VDD.P2.nwell 0.00144114f
Cext_2135 N1.$170.li1 sky130_gnd 0.0125941f
Cext_2136 N1.$172.li1 VDD.P2.nwell 0.00144114f
Cext_2137 N1.$172.li1 sky130_gnd 0.0125941f
Cext_2138 N1.$174.li1 sky130_gnd 0.0125941f
Cext_2139 N1.$176.li1 sky130_gnd 0.0125941f
Cext_2140 N1.$178.li1 VDD.$761.nwell 0.00144114f
Cext_2141 N1.$178.li1 sky130_gnd 0.0125941f
Cext_2142 N1.$18.li1 TAIL.$18.li1 0.00111142f
Cext_2143 N1.$18.li1 VSS.$366.met2 0.00165239f
Cext_2144 N1.$18.li1 VSS.$6.li1 0.0133043f
Cext_2145 N1.$180.li1 VDD.$761.nwell 0.00144114f
Cext_2146 N1.$180.li1 sky130_gnd 0.0125941f
Cext_2147 N1.$182.li1 VDD.$761.nwell 0.00144114f
Cext_2148 N1.$182.li1 sky130_gnd 0.0125941f
Cext_2149 N1.$184.li1 VDD.$761.nwell 0.00144114f
Cext_2150 N1.$184.li1 sky130_gnd 0.0125941f
Cext_2151 N1.$186.li1 VDD.$761.nwell 0.00144114f
Cext_2152 N1.$186.li1 sky130_gnd 0.0125941f
Cext_2153 N1.$188.li1 VDD.$761.nwell 0.00144114f
Cext_2154 N1.$188.li1 sky130_gnd 0.0125941f
Cext_2155 N1.$190.li1 VDD.$761.nwell 0.00144114f
Cext_2156 N1.$190.li1 sky130_gnd 0.0125941f
Cext_2157 N1.$192.li1 VDD.$761.nwell 0.00144114f
Cext_2158 N1.$192.li1 sky130_gnd 0.0125941f
Cext_2159 N1.$194.li1 VDD.$761.nwell 0.00469712f
Cext_2160 N1.$194.li1 sky130_gnd 0.0145347f
Cext_2161 N1.$196.li1 VDD.$761.nwell 0.00438357f
Cext_2162 N1.$196.li1 sky130_gnd 0.0157784f
Cext_2163 N1.$198.met1 TAIL.$221.met1 0.00165509f
Cext_2164 N1.$198.met1 TAIL.$265.met1 0.00202003f
Cext_2165 N1.$198.met1 TAIL.$339.met3 0.0022554f
Cext_2166 N1.$198.met1 TAIL.$340.met3 0.00301106f
Cext_2167 N1.$198.met1 VSS.$366.met2 0.00155799f
Cext_2168 N1.$198.met1 VSS.$6.li1 0.00338188f
Cext_2169 N1.$198.met1 sky130_gnd 0.0149001f
Cext_2170 N1.$199.met1 TAIL.$222.met1 0.00183333f
Cext_2171 N1.$199.met1 TAIL.$339.met3 0.00813409f
Cext_2172 N1.$199.met1 sky130_gnd 0.00161828f
Cext_2173 N1.$2.li1 TAIL.$2.li1 0.00107494f
Cext_2174 N1.$2.li1 TAIL.$339.met3 0.003739f
Cext_2175 N1.$2.li1 VSS.$366.met2 0.00162944f
Cext_2176 N1.$2.li1 VSS.$6.li1 0.0133043f
Cext_2177 N1.$20.li1 TAIL.$20.li1 0.00111142f
Cext_2178 N1.$20.li1 VSS.$366.met2 0.00165239f
Cext_2179 N1.$20.li1 VSS.$6.li1 0.0133043f
Cext_2180 N1.$200.met1 TAIL.$223.met1 0.00183948f
Cext_2181 N1.$200.met1 TAIL.$267.met1 0.00265291f
Cext_2182 N1.$200.met1 VSS.$366.met2 0.00202267f
Cext_2183 N1.$200.met1 VSS.$6.li1 0.00451833f
Cext_2184 N1.$200.met1 sky130_gnd 0.00776772f
Cext_2185 N1.$201.met1 TAIL.$224.met1 0.00183965f
Cext_2186 N1.$201.met1 TAIL.$268.met1 0.00265378f
Cext_2187 N1.$201.met1 VSS.$366.met2 0.00202267f
Cext_2188 N1.$201.met1 VSS.$6.li1 0.00453152f
Cext_2189 N1.$201.met1 sky130_gnd 0.00776772f
Cext_2190 N1.$202.met1 TAIL.$225.met1 0.00183965f
Cext_2191 N1.$202.met1 TAIL.$269.met1 0.00265378f
Cext_2192 N1.$202.met1 VSS.$366.met2 0.00202267f
Cext_2193 N1.$202.met1 VSS.$6.li1 0.00446555f
Cext_2194 N1.$202.met1 sky130_gnd 0.00776772f
Cext_2195 N1.$203.met1 TAIL.$226.met1 0.00183965f
Cext_2196 N1.$203.met1 TAIL.$270.met1 0.00265378f
Cext_2197 N1.$203.met1 VSS.$366.met2 0.00202267f
Cext_2198 N1.$203.met1 VSS.$6.li1 0.00453152f
Cext_2199 N1.$203.met1 sky130_gnd 0.00776772f
Cext_2200 N1.$204.met1 TAIL.$227.met1 0.00183965f
Cext_2201 N1.$204.met1 TAIL.$271.met1 0.00265378f
Cext_2202 N1.$204.met1 VSS.$366.met2 0.00202267f
Cext_2203 N1.$204.met1 VSS.$6.li1 0.00453152f
Cext_2204 N1.$204.met1 sky130_gnd 0.00776772f
Cext_2205 N1.$205.met1 TAIL.$228.met1 0.00183965f
Cext_2206 N1.$205.met1 TAIL.$272.met1 0.00265378f
Cext_2207 N1.$205.met1 VSS.$366.met2 0.00202267f
Cext_2208 N1.$205.met1 VSS.$6.li1 0.00453152f
Cext_2209 N1.$205.met1 sky130_gnd 0.00776772f
Cext_2210 N1.$206.met1 TAIL.$229.met1 0.00183965f
Cext_2211 N1.$206.met1 TAIL.$273.met1 0.00265378f
Cext_2212 N1.$206.met1 VSS.$366.met2 0.00202267f
Cext_2213 N1.$206.met1 VSS.$6.li1 0.00453152f
Cext_2214 N1.$206.met1 sky130_gnd 0.00776772f
Cext_2215 N1.$207.met1 TAIL.$230.met1 0.00183965f
Cext_2216 N1.$207.met1 TAIL.$274.met1 0.00265378f
Cext_2217 N1.$207.met1 VSS.$366.met2 0.00202267f
Cext_2218 N1.$207.met1 VSS.$6.li1 0.00453152f
Cext_2219 N1.$207.met1 sky130_gnd 0.00776772f
Cext_2220 N1.$208.met1 TAIL.$231.met1 0.00183965f
Cext_2221 N1.$208.met1 TAIL.$275.met1 0.00265378f
Cext_2222 N1.$208.met1 VSS.$366.met2 0.00202267f
Cext_2223 N1.$208.met1 VSS.$6.li1 0.00453152f
Cext_2224 N1.$208.met1 sky130_gnd 0.00776772f
Cext_2225 N1.$209.met1 TAIL.$232.met1 0.00183965f
Cext_2226 N1.$209.met1 TAIL.$276.met1 0.00265378f
Cext_2227 N1.$209.met1 VSS.$366.met2 0.00202267f
Cext_2228 N1.$209.met1 VSS.$6.li1 0.00453152f
Cext_2229 N1.$209.met1 sky130_gnd 0.00776772f
Cext_2230 N1.$210.met1 TAIL.$233.met1 0.00183965f
Cext_2231 N1.$210.met1 TAIL.$277.met1 0.00265378f
Cext_2232 N1.$210.met1 VSS.$366.met2 0.00202267f
Cext_2233 N1.$210.met1 VSS.$6.li1 0.00453152f
Cext_2234 N1.$210.met1 sky130_gnd 0.00776772f
Cext_2235 N1.$211.met1 TAIL.$234.met1 0.00183965f
Cext_2236 N1.$211.met1 TAIL.$278.met1 0.00262252f
Cext_2237 N1.$211.met1 TAIL.$340.met3 0.0126662f
Cext_2238 N1.$211.met1 VSS.$366.met2 0.00202267f
Cext_2239 N1.$211.met1 VSS.$6.li1 0.00453152f
Cext_2240 N1.$211.met1 sky130_gnd 0.00776772f
Cext_2241 N1.$212.met1 TAIL.$235.met1 0.00183965f
Cext_2242 N1.$212.met1 TAIL.$279.met1 0.00265378f
Cext_2243 N1.$212.met1 VSS.$366.met2 0.00202267f
Cext_2244 N1.$212.met1 VSS.$6.li1 0.00453152f
Cext_2245 N1.$212.met1 sky130_gnd 0.00776772f
Cext_2246 N1.$213.met1 TAIL.$236.met1 0.00183965f
Cext_2247 N1.$213.met1 TAIL.$280.met1 0.00265378f
Cext_2248 N1.$213.met1 VSS.$366.met2 0.00202267f
Cext_2249 N1.$213.met1 VSS.$6.li1 0.00453152f
Cext_2250 N1.$213.met1 sky130_gnd 0.00776772f
Cext_2251 N1.$214.met1 TAIL.$237.met1 0.00183965f
Cext_2252 N1.$214.met1 TAIL.$281.met1 0.00265378f
Cext_2253 N1.$214.met1 VSS.$366.met2 0.00202267f
Cext_2254 N1.$214.met1 VSS.$6.li1 0.00453152f
Cext_2255 N1.$214.met1 sky130_gnd 0.00776772f
Cext_2256 N1.$215.met1 TAIL.$238.met1 0.00183965f
Cext_2257 N1.$215.met1 TAIL.$282.met1 0.00265378f
Cext_2258 N1.$215.met1 VSS.$366.met2 0.00202267f
Cext_2259 N1.$215.met1 VSS.$6.li1 0.00453152f
Cext_2260 N1.$215.met1 sky130_gnd 0.00776772f
Cext_2261 N1.$216.met1 TAIL.$239.met1 0.00183965f
Cext_2262 N1.$216.met1 TAIL.$283.met1 0.00265378f
Cext_2263 N1.$216.met1 VSS.$366.met2 0.00202267f
Cext_2264 N1.$216.met1 VSS.$6.li1 0.00453152f
Cext_2265 N1.$216.met1 sky130_gnd 0.00776772f
Cext_2266 N1.$217.met1 TAIL.$240.met1 0.00183965f
Cext_2267 N1.$217.met1 TAIL.$284.met1 0.00265378f
Cext_2268 N1.$217.met1 VSS.$366.met2 0.00202267f
Cext_2269 N1.$217.met1 VSS.$6.li1 0.00453152f
Cext_2270 N1.$217.met1 sky130_gnd 0.00776772f
Cext_2271 N1.$218.met1 TAIL.$241.met1 0.00183965f
Cext_2272 N1.$218.met1 TAIL.$285.met1 0.00265378f
Cext_2273 N1.$218.met1 VSS.$366.met2 0.0133654f
Cext_2274 N1.$218.met1 VSS.$415.met3 0.00632145f
Cext_2275 N1.$218.met1 VSS.$6.li1 0.00446555f
Cext_2276 N1.$218.met1 sky130_gnd 0.00776772f
Cext_2277 N1.$219.met1 TAIL.$242.met1 0.00187092f
Cext_2278 N1.$219.met1 TAIL.$286.met1 0.00145695f
Cext_2279 N1.$219.met1 VSS.$220.met1 0.00395506f
Cext_2280 N1.$219.met1 VSS.$366.met2 0.0154355f
Cext_2281 N1.$219.met1 VSS.$368.met2 0.00163955f
Cext_2282 N1.$219.met1 VSS.$415.met3 0.00281833f
Cext_2283 N1.$219.met1 VSS.$6.li1 0.0062583f
Cext_2284 N1.$219.met1 sky130_gnd 0.0043154f
Cext_2285 N1.$22.li1 TAIL.$22.li1 0.00111142f
Cext_2286 N1.$22.li1 VSS.$366.met2 0.00165239f
Cext_2287 N1.$22.li1 VSS.$6.li1 0.0133043f
Cext_2288 N1.$220.met1 TAIL.$243.met1 0.00187373f
Cext_2289 N1.$220.met1 TAIL.$287.met1 0.00145695f
Cext_2290 N1.$220.met1 VSS.$220.met1 0.0047266f
Cext_2291 N1.$220.met1 VSS.$366.met2 0.00475103f
Cext_2292 N1.$220.met1 VSS.$368.met2 0.00499731f
Cext_2293 N1.$220.met1 VSS.$6.li1 0.0062583f
Cext_2294 N1.$220.met1 sky130_gnd 0.0043154f
Cext_2295 N1.$221.met1 TAIL.$244.met1 0.00183965f
Cext_2296 N1.$221.met1 TAIL.$288.met1 0.0026601f
Cext_2297 N1.$221.met1 VSS.$220.met1 0.00202267f
Cext_2298 N1.$221.met1 VSS.$6.li1 0.00453152f
Cext_2299 N1.$221.met1 sky130_gnd 0.00776772f
Cext_2300 N1.$222.met1 TAIL.$245.met1 0.00183965f
Cext_2301 N1.$222.met1 TAIL.$289.met1 0.0026601f
Cext_2302 N1.$222.met1 VSS.$220.met1 0.00202267f
Cext_2303 N1.$222.met1 VSS.$6.li1 0.00453152f
Cext_2304 N1.$222.met1 sky130_gnd 0.00776772f
Cext_2305 N1.$223.met1 TAIL.$246.met1 0.00183965f
Cext_2306 N1.$223.met1 TAIL.$290.met1 0.0026601f
Cext_2307 N1.$223.met1 VSS.$220.met1 0.00202267f
Cext_2308 N1.$223.met1 VSS.$6.li1 0.00453152f
Cext_2309 N1.$223.met1 sky130_gnd 0.00776772f
Cext_2310 N1.$224.met1 TAIL.$247.met1 0.00183965f
Cext_2311 N1.$224.met1 TAIL.$291.met1 0.0026601f
Cext_2312 N1.$224.met1 VSS.$220.met1 0.00202267f
Cext_2313 N1.$224.met1 VSS.$6.li1 0.00453152f
Cext_2314 N1.$224.met1 sky130_gnd 0.00776772f
Cext_2315 N1.$225.met1 TAIL.$248.met1 0.00183965f
Cext_2316 N1.$225.met1 TAIL.$292.met1 0.0026601f
Cext_2317 N1.$225.met1 VSS.$220.met1 0.00202267f
Cext_2318 N1.$225.met1 VSS.$6.li1 0.00453152f
Cext_2319 N1.$225.met1 sky130_gnd 0.00776772f
Cext_2320 N1.$226.met1 TAIL.$249.met1 0.00183965f
Cext_2321 N1.$226.met1 TAIL.$293.met1 0.0026601f
Cext_2322 N1.$226.met1 VSS.$220.met1 0.00202267f
Cext_2323 N1.$226.met1 VSS.$6.li1 0.00453152f
Cext_2324 N1.$226.met1 sky130_gnd 0.00776772f
Cext_2325 N1.$227.met1 TAIL.$250.met1 0.00183965f
Cext_2326 N1.$227.met1 TAIL.$294.met1 0.0026601f
Cext_2327 N1.$227.met1 VSS.$220.met1 0.00202267f
Cext_2328 N1.$227.met1 VSS.$6.li1 0.00453152f
Cext_2329 N1.$227.met1 sky130_gnd 0.00776772f
Cext_2330 N1.$228.met1 TAIL.$251.met1 0.00183965f
Cext_2331 N1.$228.met1 TAIL.$295.met1 0.0026601f
Cext_2332 N1.$228.met1 VSS.$220.met1 0.00202267f
Cext_2333 N1.$228.met1 VSS.$6.li1 0.00453152f
Cext_2334 N1.$228.met1 sky130_gnd 0.00776772f
Cext_2335 N1.$229.met1 TAIL.$252.met1 0.00183965f
Cext_2336 N1.$229.met1 TAIL.$296.met1 0.0026601f
Cext_2337 N1.$229.met1 VSS.$220.met1 0.00202267f
Cext_2338 N1.$229.met1 VSS.$6.li1 0.00453152f
Cext_2339 N1.$229.met1 sky130_gnd 0.00776772f
Cext_2340 N1.$230.met1 TAIL.$253.met1 0.00183965f
Cext_2341 N1.$230.met1 TAIL.$297.met1 0.0026601f
Cext_2342 N1.$230.met1 VSS.$220.met1 0.00202267f
Cext_2343 N1.$230.met1 VSS.$6.li1 0.00453152f
Cext_2344 N1.$230.met1 sky130_gnd 0.00776772f
Cext_2345 N1.$231.met1 TAIL.$254.met1 0.00183965f
Cext_2346 N1.$231.met1 TAIL.$298.met1 0.0026601f
Cext_2347 N1.$231.met1 VSS.$220.met1 0.00202267f
Cext_2348 N1.$231.met1 VSS.$6.li1 0.00453152f
Cext_2349 N1.$231.met1 sky130_gnd 0.00776772f
Cext_2350 N1.$232.met1 TAIL.$255.met1 0.00183965f
Cext_2351 N1.$232.met1 TAIL.$299.met1 0.0026601f
Cext_2352 N1.$232.met1 VSS.$220.met1 0.00202267f
Cext_2353 N1.$232.met1 VSS.$6.li1 0.00453152f
Cext_2354 N1.$232.met1 sky130_gnd 0.00776772f
Cext_2355 N1.$233.met1 TAIL.$256.met1 0.00183965f
Cext_2356 N1.$233.met1 TAIL.$300.met1 0.0026601f
Cext_2357 N1.$233.met1 VSS.$220.met1 0.00202267f
Cext_2358 N1.$233.met1 VSS.$6.li1 0.00453152f
Cext_2359 N1.$233.met1 sky130_gnd 0.00776772f
Cext_2360 N1.$234.met1 TAIL.$257.met1 0.00183965f
Cext_2361 N1.$234.met1 TAIL.$301.met1 0.0026601f
Cext_2362 N1.$234.met1 VSS.$220.met1 0.00202267f
Cext_2363 N1.$234.met1 VSS.$6.li1 0.00453152f
Cext_2364 N1.$234.met1 sky130_gnd 0.00776772f
Cext_2365 N1.$235.met1 TAIL.$258.met1 0.00183965f
Cext_2366 N1.$235.met1 TAIL.$302.met1 0.0026601f
Cext_2367 N1.$235.met1 VSS.$220.met1 0.00202267f
Cext_2368 N1.$235.met1 VSS.$6.li1 0.00453152f
Cext_2369 N1.$235.met1 sky130_gnd 0.00776772f
Cext_2370 N1.$236.met1 TAIL.$259.met1 0.00183965f
Cext_2371 N1.$236.met1 TAIL.$303.met1 0.0026601f
Cext_2372 N1.$236.met1 VSS.$220.met1 0.00202267f
Cext_2373 N1.$236.met1 VSS.$6.li1 0.00453152f
Cext_2374 N1.$236.met1 sky130_gnd 0.00776772f
Cext_2375 N1.$237.met1 TAIL.$260.met1 0.00183965f
Cext_2376 N1.$237.met1 TAIL.$304.met1 0.0026601f
Cext_2377 N1.$237.met1 VSS.$220.met1 0.00202267f
Cext_2378 N1.$237.met1 VSS.$6.li1 0.00453152f
Cext_2379 N1.$237.met1 sky130_gnd 0.00776772f
Cext_2380 N1.$238.met1 TAIL.$261.met1 0.00183965f
Cext_2381 N1.$238.met1 TAIL.$305.met1 0.0026601f
Cext_2382 N1.$238.met1 VSS.$220.met1 0.00202267f
Cext_2383 N1.$238.met1 VSS.$6.li1 0.00453152f
Cext_2384 N1.$238.met1 sky130_gnd 0.00776772f
Cext_2385 N1.$239.met1 TAIL.$262.met1 0.00183965f
Cext_2386 N1.$239.met1 TAIL.$306.met1 0.0026601f
Cext_2387 N1.$239.met1 VSS.$220.met1 0.00202267f
Cext_2388 N1.$239.met1 VSS.$6.li1 0.00453152f
Cext_2389 N1.$239.met1 sky130_gnd 0.00776772f
Cext_2390 N1.$24.li1 TAIL.$24.li1 0.00111142f
Cext_2391 N1.$24.li1 VSS.$366.met2 0.00165239f
Cext_2392 N1.$24.li1 VSS.$6.li1 0.0133043f
Cext_2393 N1.$240.met1 TAIL.$263.met1 0.00183965f
Cext_2394 N1.$240.met1 TAIL.$307.met1 0.0026601f
Cext_2395 N1.$240.met1 VSS.$220.met1 0.00202267f
Cext_2396 N1.$240.met1 VSS.$6.li1 0.00453152f
Cext_2397 N1.$240.met1 sky130_gnd 0.00776772f
Cext_2398 N1.$241.met1 TAIL.$264.met1 0.0016608f
Cext_2399 N1.$241.met1 TAIL.$308.met1 0.00240148f
Cext_2400 N1.$241.met1 VSS.$220.met1 0.00182602f
Cext_2401 N1.$241.met1 VSS.$6.li1 0.00409096f
Cext_2402 N1.$241.met1 sky130_gnd 0.0148305f
Cext_2403 N1.$242.met1 TAIL.$266.met1 0.00216955f
Cext_2404 N1.$242.met1 TAIL.$340.met3 0.00497636f
Cext_2405 N1.$242.met1 VSS.$366.met2 0.00717452f
Cext_2406 N1.$242.met1 VSS.$6.li1 0.00704649f
Cext_2407 N1.$242.met1 sky130_gnd 0.0120364f
Cext_2408 N1.$243.met1 PB.$5900.met1 0.00127778f
Cext_2409 N1.$243.met1 PB.$5938.met3 0.00277304f
Cext_2410 N1.$243.met1 VDD.$455.met1 0.00136434f
Cext_2411 N1.$243.met1 VDD.$488.met2 0.00151354f
Cext_2412 N1.$243.met1 VDD.$489.met2 0.00215918f
Cext_2413 N1.$243.met1 VDD.$728.nwell 0.00309279f
Cext_2414 N1.$243.met1 sky130_gnd 0.0162576f
Cext_2415 N1.$244.met1 VDD.$739.nwell 0.00112678f
Cext_2416 N1.$244.met1 VDD.$740.nwell 0.00143099f
Cext_2417 N1.$244.met1 sky130_gnd 0.0162576f
Cext_2418 N1.$245.met1 PB.$5938.met3 0.00370115f
Cext_2419 N1.$245.met1 VDD.P1.nwell 0.0010666f
Cext_2420 N1.$245.met1 sky130_gnd 0.0132568f
Cext_2421 N1.$246.met1 VDD.P1.nwell 0.0010666f
Cext_2422 N1.$246.met1 sky130_gnd 0.0132568f
Cext_2423 N1.$247.met1 PB.$5938.met3 0.00254995f
Cext_2424 N1.$247.met1 VDD.P1.nwell 0.0010666f
Cext_2425 N1.$247.met1 sky130_gnd 0.0132568f
Cext_2426 N1.$248.met1 sky130_gnd 0.0132494f
Cext_2427 N1.$249.met1 sky130_gnd 0.00204553f
Cext_2428 N1.$250.met1 PB.$5938.met3 0.00209618f
Cext_2429 N1.$250.met1 VDD.P1.nwell 0.0010666f
Cext_2430 N1.$250.met1 sky130_gnd 0.0132568f
Cext_2431 N1.$251.met1 VDD.P1.nwell 0.00104398f
Cext_2432 N1.$251.met1 sky130_gnd 0.0130326f
Cext_2433 N1.$252.met1 PB.$5938.met3 0.00213345f
Cext_2434 N1.$252.met1 VDD.P1.nwell 0.0010666f
Cext_2435 N1.$252.met1 sky130_gnd 0.0132568f
Cext_2436 N1.$253.met1 VDD.P1.nwell 0.0010666f
Cext_2437 N1.$253.met1 sky130_gnd 0.0132568f
Cext_2438 N1.$254.met1 PB.$5938.met3 0.00249082f
Cext_2439 N1.$254.met1 VDD.$504.met3 0.00111629f
Cext_2440 N1.$254.met1 sky130_gnd 0.0132568f
Cext_2441 N1.$255.met1 sky130_gnd 0.0132568f
Cext_2442 N1.$256.met1 PB.$5938.met3 0.00186599f
Cext_2443 N1.$256.met1 VDD.$750.nwell 0.0010666f
Cext_2444 N1.$256.met1 sky130_gnd 0.0132568f
Cext_2445 N1.$257.met1 VDD.$750.nwell 0.0010666f
Cext_2446 N1.$257.met1 sky130_gnd 0.0132568f
Cext_2447 N1.$258.met1 PB.$5945.met3 0.00223377f
Cext_2448 N1.$258.met1 VDD.$750.nwell 0.0010666f
Cext_2449 N1.$258.met1 sky130_gnd 0.0132568f
Cext_2450 N1.$259.met1 VDD.$750.nwell 0.0010666f
Cext_2451 N1.$259.met1 sky130_gnd 0.0132568f
Cext_2452 N1.$26.li1 TAIL.$26.li1 0.00111142f
Cext_2453 N1.$26.li1 VSS.$366.met2 0.00165239f
Cext_2454 N1.$26.li1 VSS.$6.li1 0.0133043f
Cext_2455 N1.$260.met1 PB.$5945.met3 0.00247201f
Cext_2456 N1.$260.met1 VDD.$504.met3 0.00110692f
Cext_2457 N1.$260.met1 VDD.$750.nwell 0.0010666f
Cext_2458 N1.$260.met1 sky130_gnd 0.0132568f
Cext_2459 N1.$261.met1 VDD.$750.nwell 0.0010666f
Cext_2460 N1.$261.met1 sky130_gnd 0.0132568f
Cext_2461 N1.$262.met1 PB.$5945.met3 0.00203941f
Cext_2462 N1.$262.met1 VDD.$750.nwell 0.0010666f
Cext_2463 N1.$262.met1 sky130_gnd 0.0132568f
Cext_2464 N1.$263.met1 VDD.$750.nwell 0.0010666f
Cext_2465 N1.$263.met1 sky130_gnd 0.0132568f
Cext_2466 N1.$264.met1 VDD.$750.nwell 0.0046444f
Cext_2467 N1.$264.met1 sky130_gnd 0.0155255f
Cext_2468 N1.$265.met1 VDD.$750.nwell 0.0046444f
Cext_2469 N1.$265.met1 sky130_gnd 0.0155255f
Cext_2470 N1.$266.met1 VDD.$455.met1 0.0017469f
Cext_2471 N1.$267.met1 PB.$5945.met3 0.00647955f
Cext_2472 N1.$267.met1 VDD.$294.li1 0.00591073f
Cext_2473 N1.$267.met1 VDD.$458.met1 0.00163608f
Cext_2474 N1.$267.met1 VDD.$750.nwell 0.00447045f
Cext_2475 N1.$267.met1 sky130_gnd 0.0135104f
Cext_2476 N1.$268.met1 PB.$5945.met3 0.00317919f
Cext_2477 N1.$268.met1 VDD.$295.li1 0.00649081f
Cext_2478 N1.$268.met1 VDD.$445.met1 0.00140046f
Cext_2479 N1.$268.met1 VDD.$460.met1 0.00182229f
Cext_2480 N1.$268.met1 VDD.$750.nwell 0.00191964f
Cext_2481 N1.$268.met1 sky130_gnd 0.0064927f
Cext_2482 N1.$269.met1 VDD.$296.li1 0.00632392f
Cext_2483 N1.$269.met1 VDD.$446.met1 0.00183333f
Cext_2484 N1.$269.met1 VDD.$461.met1 0.00238554f
Cext_2485 N1.$269.met1 VDD.$505.met3 0.00145129f
Cext_2486 N1.$269.met1 VDD.$750.nwell 0.00195358f
Cext_2487 N1.$269.met1 sky130_gnd 0.00649879f
Cext_2488 N1.$270.met1 VDD.$297.li1 0.00639308f
Cext_2489 N1.$270.met1 VDD.$447.met1 0.00183333f
Cext_2490 N1.$270.met1 VDD.$462.met1 0.00238554f
Cext_2491 N1.$270.met1 VDD.$504.met3 0.00686508f
Cext_2492 N1.$270.met1 VDD.$505.met3 0.00825014f
Cext_2493 N1.$270.met1 VDD.$750.nwell 0.00158074f
Cext_2494 N1.$270.met1 sky130_gnd 0.00649879f
Cext_2495 N1.$271.met1 VDD.$298.li1 0.00623491f
Cext_2496 N1.$271.met1 VDD.$448.met1 0.00183333f
Cext_2497 N1.$271.met1 VDD.$463.met1 0.00238554f
Cext_2498 N1.$271.met1 VDD.$504.met3 0.00109313f
Cext_2499 N1.$271.met1 VDD.$505.met3 0.00140365f
Cext_2500 N1.$271.met1 VDD.$750.nwell 0.00158074f
Cext_2501 N1.$271.met1 sky130_gnd 0.00649879f
Cext_2502 N1.$272.met1 VDD.$299.li1 0.0092375f
Cext_2503 N1.$272.met1 VDD.$449.met1 0.00183333f
Cext_2504 N1.$272.met1 VDD.$456.met1 0.00834062f
Cext_2505 N1.$272.met1 VDD.$490.met2 0.00186735f
Cext_2506 N1.$273.met1 VDD.$300.li1 0.00640217f
Cext_2507 N1.$273.met1 VDD.$450.met1 0.00183333f
Cext_2508 N1.$273.met1 VDD.$465.met1 0.00238554f
Cext_2509 N1.$273.met1 VDD.$490.met2 0.00573214f
Cext_2510 N1.$273.met1 VDD.$750.nwell 0.00158074f
Cext_2511 N1.$273.met1 sky130_gnd 0.00649879f
Cext_2512 N1.$274.met1 VDD.$301.li1 0.00647487f
Cext_2513 N1.$274.met1 VDD.$451.met1 0.00183333f
Cext_2514 N1.$274.met1 VDD.$466.met1 0.00238554f
Cext_2515 N1.$274.met1 VDD.$505.met3 0.00283864f
Cext_2516 N1.$274.met1 VDD.$750.nwell 0.00158074f
Cext_2517 N1.$274.met1 sky130_gnd 0.00649879f
Cext_2518 N1.$275.met1 VDD.$302.li1 0.00647487f
Cext_2519 N1.$275.met1 VDD.$452.met1 0.00183333f
Cext_2520 N1.$275.met1 VDD.$467.met1 0.00238554f
Cext_2521 N1.$275.met1 VDD.$750.nwell 0.00195358f
Cext_2522 N1.$275.met1 sky130_gnd 0.00649879f
Cext_2523 N1.$276.met1 VDD.$303.li1 0.00647487f
Cext_2524 N1.$276.met1 VDD.$453.met1 0.00183333f
Cext_2525 N1.$276.met1 VDD.$468.met1 0.00238554f
Cext_2526 N1.$276.met1 VDD.$750.nwell 0.00211832f
Cext_2527 N1.$276.met1 sky130_gnd 0.00649879f
Cext_2528 N1.$277.met1 VDD.$304.li1 0.0057567f
Cext_2529 N1.$277.met1 VDD.$454.met1 0.00165509f
Cext_2530 N1.$277.met1 VDD.$469.met1 0.00215361f
Cext_2531 N1.$277.met1 VDD.$750.nwell 0.00437511f
Cext_2532 N1.$277.met1 sky130_gnd 0.0125373f
Cext_2533 N1.$278.met1 PB.$5945.met3 0.00363599f
Cext_2534 N1.$278.met1 VDD.$750.nwell 0.00309495f
Cext_2535 N1.$278.met1 sky130_gnd 0.0162576f
Cext_2536 N1.$279.met1 VDD.$750.nwell 0.00435175f
Cext_2537 N1.$279.met1 sky130_gnd 0.0168114f
Cext_2538 N1.$28.li1 TAIL.$28.li1 0.00111142f
Cext_2539 N1.$28.li1 VSS.$366.met2 0.00165239f
Cext_2540 N1.$28.li1 VSS.$6.li1 0.0133043f
Cext_2541 N1.$280.met1 sky130_gnd 0.0028186f
Cext_2542 N1.$281.met1 PB.$5945.met3 0.00403344f
Cext_2543 N1.$281.met1 VDD.$505.met3 0.00105693f
Cext_2544 N1.$281.met1 VDD.P2.nwell 0.0010666f
Cext_2545 N1.$281.met1 sky130_gnd 0.0132568f
Cext_2546 N1.$282.met1 sky130_gnd 0.0123456f
Cext_2547 N1.$283.met1 PB.$5945.met3 0.00370115f
Cext_2548 N1.$283.met1 VDD.P2.nwell 0.0010666f
Cext_2549 N1.$283.met1 sky130_gnd 0.0132568f
Cext_2550 N1.$284.met1 VDD.P2.nwell 0.0010666f
Cext_2551 N1.$284.met1 sky130_gnd 0.0132568f
Cext_2552 N1.$285.met1 PB.$5945.met3 0.00409614f
Cext_2553 N1.$285.met1 VDD.$505.met3 0.00108817f
Cext_2554 N1.$285.met1 VDD.P2.nwell 0.0010666f
Cext_2555 N1.$285.met1 sky130_gnd 0.0132568f
Cext_2556 N1.$286.met1 VDD.P2.nwell 0.0010666f
Cext_2557 N1.$286.met1 sky130_gnd 0.0132568f
Cext_2558 N1.$287.met1 PB.$5945.met3 0.00393313f
Cext_2559 N1.$287.met1 VDD.$505.met3 0.00100695f
Cext_2560 N1.$287.met1 VDD.P2.nwell 0.0010666f
Cext_2561 N1.$287.met1 sky130_gnd 0.0132568f
Cext_2562 N1.$288.met1 VDD.P2.nwell 0.0010666f
Cext_2563 N1.$288.met1 sky130_gnd 0.0132568f
Cext_2564 N1.$289.met1 PB.$5931.met2 0.00901522f
Cext_2565 N1.$289.met1 PB.$5945.met3 0.00374504f
Cext_2566 N1.$289.met1 sky130_gnd 0.0132568f
Cext_2567 N1.$290.met1 sky130_gnd 0.0132568f
Cext_2568 N1.$291.met1 PB.$5945.met3 0.00415256f
Cext_2569 N1.$291.met1 VDD.$761.nwell 0.0010666f
Cext_2570 N1.$291.met1 sky130_gnd 0.0132568f
Cext_2571 N1.$292.met1 VDD.$761.nwell 0.0010666f
Cext_2572 N1.$292.met1 sky130_gnd 0.0132568f
Cext_2573 N1.$293.met1 PB.$5945.met3 0.00383281f
Cext_2574 N1.$293.met1 VDD.$761.nwell 0.0010666f
Cext_2575 N1.$293.met1 sky130_gnd 0.0132568f
Cext_2576 N1.$294.met1 VDD.$761.nwell 0.0010666f
Cext_2577 N1.$294.met1 sky130_gnd 0.0132568f
Cext_2578 N1.$295.met1 PB.$5945.met3 0.00384535f
Cext_2579 N1.$295.met1 VDD.$761.nwell 0.0010666f
Cext_2580 N1.$295.met1 sky130_gnd 0.0132568f
Cext_2581 N1.$296.met1 VDD.$761.nwell 0.0010666f
Cext_2582 N1.$296.met1 sky130_gnd 0.0132568f
Cext_2583 N1.$297.met1 PB.$5945.met3 0.00415256f
Cext_2584 N1.$297.met1 VDD.$506.met3 0.00111629f
Cext_2585 N1.$297.met1 VDD.$761.nwell 0.0010666f
Cext_2586 N1.$297.met1 sky130_gnd 0.0132568f
Cext_2587 N1.$298.met1 VDD.$761.nwell 0.0010666f
Cext_2588 N1.$298.met1 sky130_gnd 0.0132568f
Cext_2589 N1.$299.met1 PB.$5933.met2 0.0033408f
Cext_2590 N1.$299.met1 PB.$5945.met3 0.00337267f
Cext_2591 N1.$299.met1 VDD.$761.nwell 0.0046444f
Cext_2592 N1.$299.met1 VSS.$311.met1 0.00127136f
Cext_2593 N1.$299.met1 sky130_gnd 0.0155255f
Cext_2594 N1.$30.li1 TAIL.$30.li1 0.00111142f
Cext_2595 N1.$30.li1 VSS.$366.met2 0.00165239f
Cext_2596 N1.$30.li1 VSS.$6.li1 0.0133043f
Cext_2597 N1.$300.met1 VDD.$761.nwell 0.00423802f
Cext_2598 N1.$300.met1 sky130_gnd 0.0178259f
Cext_2599 N1.$301.met2 TAIL.$339.met3 0.017178f
Cext_2600 N1.$301.met2 TAIL.$340.met3 0.0146911f
Cext_2601 N1.$301.met2 VSS.$366.met2 0.00416074f
Cext_2602 N1.$302.met2 VSS.$366.met2 0.0127233f
Cext_2603 N1.$302.met2 VSS.$6.li1 0.0137204f
Cext_2604 N1.$302.met2 sky130_gnd 0.0121413f
Cext_2605 N1.$303.met2 VDD.$280.li1 0.00102621f
Cext_2606 N1.$303.met2 VDD.$284.li1 0.00102621f
Cext_2607 N1.$303.met2 VDD.$286.li1 0.00102621f
Cext_2608 N1.$303.met2 VDD.$288.li1 0.00102621f
Cext_2609 N1.$303.met2 VDD.$290.li1 0.00109905f
Cext_2610 N1.$303.met2 VDD.$292.li1 0.00101767f
Cext_2611 N1.$303.met2 VDD.$299.li1 0.00700377f
Cext_2612 N1.$303.met2 VDD.$304.li1 0.00278678f
Cext_2613 N1.$303.met2 VDD.$447.met1 0.00115161f
Cext_2614 N1.$303.met2 VDD.$448.met1 0.00145752f
Cext_2615 N1.$303.met2 VDD.$449.met1 0.00133606f
Cext_2616 N1.$303.met2 VDD.$450.met1 0.00160548f
Cext_2617 N1.$303.met2 VDD.$451.met1 0.00278917f
Cext_2618 N1.$303.met2 VDD.$452.met1 0.00278917f
Cext_2619 N1.$303.met2 VDD.$453.met1 0.00283593f
Cext_2620 N1.$303.met2 VDD.$454.met1 0.00252108f
Cext_2621 N1.$303.met2 VDD.$487.met2 0.0156225f
Cext_2622 N1.$303.met2 VDD.$489.met2 0.0427511f
Cext_2623 N1.$303.met2 VDD.$490.met2 0.00224359f
Cext_2624 N1.$303.met2 VDD.$491.met2 0.00100603f
Cext_2625 N1.$303.met2 VDD.$504.met3 0.0593061f
Cext_2626 N1.$303.met2 VDD.$739.nwell 0.00202365f
Cext_2627 N1.$303.met2 VDD.$750.nwell 0.00917277f
Cext_2628 N1.$303.met2 VDD.P1.psdm 0.0011294f
Cext_2629 N1.$303.met2 sky130_gnd 0.0555048f
Cext_2630 N1.$304.met2 PB.$5931.met2 0.00304193f
Cext_2631 N1.$304.met2 PB.$5933.met2 0.0202099f
Cext_2632 N1.$304.met2 PB.$5938.met3 0.0903501f
Cext_2633 N1.$304.met2 PB.$5945.met3 0.109915f
Cext_2634 N1.$304.met2 VDD.$272.li1 0.0029152f
Cext_2635 N1.$304.met2 VDD.$274.li1 0.00197548f
Cext_2636 N1.$304.met2 VDD.$276.li1 0.00111323f
Cext_2637 N1.$304.met2 VDD.$445.met1 0.00131813f
Cext_2638 N1.$304.met2 VDD.$446.met1 0.00145752f
Cext_2639 N1.$304.met2 VDD.$455.met1 0.00396284f
Cext_2640 N1.$304.met2 VDD.$487.met2 0.00139469f
Cext_2641 N1.$304.met2 VDD.$488.met2 0.0201196f
Cext_2642 N1.$304.met2 VDD.$489.met2 0.0120778f
Cext_2643 N1.$304.met2 VDD.$491.met2 0.00137518f
Cext_2644 N1.$304.met2 VDD.$504.met3 0.0644912f
Cext_2645 N1.$304.met2 VDD.$505.met3 0.018779f
Cext_2646 N1.$304.met2 VDD.$728.nwell 0.00211415f
Cext_2647 N1.$304.met2 VDD.$750.nwell 0.00139333f
Cext_2648 N1.$304.met2 VDD.P1.nwell 0.0058135f
Cext_2649 N1.$304.met2 sky130_gnd 0.668797f
Cext_2650 N1.$305.met2 PB.$5740.li1 0.00202131f
Cext_2651 N1.$305.met2 PB.$5902.met1 0.00234207f
Cext_2652 N1.$305.met2 PB.$5929.met2 0.0111111f
Cext_2653 N1.$305.met2 PB.$5932.met2 0.0271812f
Cext_2654 N1.$305.met2 PB.$5933.met2 0.00158623f
Cext_2655 N1.$305.met2 S.$14.li1 0.00236158f
Cext_2656 N1.$305.met2 S.$27.met1 0.00330003f
Cext_2657 N1.$305.met2 S.$40.poly 0.00118676f
Cext_2658 N1.$305.met2 VREF.$103.met2 0.0102041f
Cext_2659 N1.$305.met2 VSS.$405.met2 0.00385417f
Cext_2660 N1.$305.met2 VSS.$407.met2 0.0350347f
Cext_2661 N1.$305.met2 VSS.$408.met2 0.0381714f
Cext_2662 N1.$305.met2 VSS.$427.met3 0.039447f
Cext_2663 N1.$305.met2 VSS.$428.met3 0.0412043f
Cext_2664 N1.$305.met2 sky130_gnd 0.738837f
Cext_2665 N1.$306.met2 PB.$5931.met2 0.00846915f
Cext_2666 N1.$306.met2 PB.$5945.met3 0.0334995f
Cext_2667 N1.$306.met2 VDD.$294.li1 0.00213996f
Cext_2668 N1.$306.met2 VDD.$295.li1 0.00218911f
Cext_2669 N1.$306.met2 VDD.$296.li1 0.00229959f
Cext_2670 N1.$306.met2 VDD.$297.li1 0.00243844f
Cext_2671 N1.$306.met2 VDD.$298.li1 0.00224405f
Cext_2672 N1.$306.met2 VDD.$299.li1 0.00307423f
Cext_2673 N1.$306.met2 VDD.$300.li1 0.00243844f
Cext_2674 N1.$306.met2 VDD.$301.li1 0.00243844f
Cext_2675 N1.$306.met2 VDD.$302.li1 0.00243844f
Cext_2676 N1.$306.met2 VDD.$303.li1 0.00211941f
Cext_2677 N1.$306.met2 VDD.$490.met2 0.0194444f
Cext_2678 N1.$306.met2 VDD.$491.met2 0.0109822f
Cext_2679 N1.$306.met2 VDD.$492.met2 0.00501493f
Cext_2680 N1.$306.met2 VDD.$505.met3 0.0590818f
Cext_2681 N1.$306.met2 VDD.$750.nwell 0.0196571f
Cext_2682 N1.$306.met2 VDD.P2.nwell 0.00335779f
Cext_2683 N1.$306.met2 sky130_gnd 0.125682f
Cext_2684 N1.$307.met2 VDD.$299.li1 0.00346668f
Cext_2685 N1.$307.met2 VDD.$302.li1 0.00218069f
Cext_2686 N1.$307.met2 VDD.$464.met1 0.00143243f
Cext_2687 N1.$307.met2 VDD.$465.met1 0.00944883f
Cext_2688 N1.$307.met2 VDD.$469.met1 0.00425468f
Cext_2689 N1.$307.met2 VDD.$490.met2 0.0205113f
Cext_2690 N1.$307.met2 VDD.$491.met2 0.011532f
Cext_2691 N1.$307.met2 VDD.$492.met2 0.00218228f
Cext_2692 N1.$307.met2 VDD.$505.met3 0.00496108f
Cext_2693 N1.$307.met2 VDD.$750.nwell 0.0230431f
Cext_2694 N1.$307.met2 VDD.$761.nwell 0.00143308f
Cext_2695 N1.$307.met2 VDD.P2.nwell 0.00478039f
Cext_2696 N1.$307.met2 VDD.P2.psdm 0.00209795f
Cext_2697 N1.$307.met2 sky130_gnd 0.189655f
Cext_2698 N1.$308.met3 NB.$275.met3 0.004625f
Cext_2699 N1.$308.met3 NB.$276.met3 0.00949342f
Cext_2700 N1.$308.met3 NB.$299.poly 0.0479059f
Cext_2701 N1.$308.met3 NB.$300.poly 0.00358404f
Cext_2702 N1.$308.met3 NB.P0.poly 0.169459f
Cext_2703 N1.$308.met3 PB.$5566.li1 0.00218665f
Cext_2704 N1.$308.met3 PB.$5568.li1 0.00322477f
Cext_2705 N1.$308.met3 PB.$5810.met1 0.00301231f
Cext_2706 N1.$308.met3 PB.$5811.met1 0.00967956f
Cext_2707 N1.$308.met3 PB.$5812.met1 0.0145162f
Cext_2708 N1.$308.met3 PB.$5820.met1 0.0118966f
Cext_2709 N1.$308.met3 PB.$5920.met2 0.00404213f
Cext_2710 N1.$308.met3 PB.P1.nsdm 0.00336499f
Cext_2711 N1.$308.met3 TAIL.$184.li1 0.00183424f
Cext_2712 N1.$308.met3 TAIL.$267.met1 0.00360905f
Cext_2713 N1.$308.met3 TAIL.$268.met1 0.00884934f
Cext_2714 N1.$308.met3 TAIL.$269.met1 0.0124794f
Cext_2715 N1.$308.met3 TAIL.$277.met1 0.011996f
Cext_2716 N1.$308.met3 TAIL.$313.met1 0.00263968f
Cext_2717 N1.$308.met3 TAIL.$314.met1 0.00204721f
Cext_2718 N1.$308.met3 TAIL.$315.met1 0.00351752f
Cext_2719 N1.$308.met3 TAIL.$324.met1 0.0121252f
Cext_2720 N1.$308.met3 TAIL.$335.met2 0.00286803f
Cext_2721 N1.$308.met3 TAIL.$336.met2 0.00337171f
Cext_2722 N1.$308.met3 TAIL.$340.met3 0.346368f
Cext_2723 N1.$308.met3 TAIL.$341.met3 0.225083f
Cext_2724 N1.$308.met3 TAIL.$94.li1 0.00331288f
Cext_2725 N1.$308.met3 TAIL.$96.li1 0.0048061f
Cext_2726 N1.$308.met3 TAIL.P0.nsdm 0.00340108f
Cext_2727 N1.$308.met3 TAIL.P2.nsdm 0.00553012f
Cext_2728 N1.$308.met3 VREF.$107.met3 0.00318966f
Cext_2729 N1.$308.met3 VSS.$18.li1 0.00298065f
Cext_2730 N1.$308.met3 VSS.$20.li1 0.00483236f
Cext_2731 N1.$308.met3 VSS.$22.li1 0.0105889f
Cext_2732 N1.$308.met3 VSS.$239.met1 0.00565857f
Cext_2733 N1.$308.met3 VSS.$240.met1 0.0121374f
Cext_2734 N1.$308.met3 VSS.$243.met1 0.00129099f
Cext_2735 N1.$308.met3 VSS.$248.met1 0.0102874f
Cext_2736 N1.$308.met3 VSS.$252.met1 0.0036787f
Cext_2737 N1.$308.met3 VSS.$267.met1 0.00734817f
Cext_2738 N1.$308.met3 VSS.$366.met2 0.0102189f
Cext_2739 N1.$308.met3 VSS.$377.met2 0.00471832f
Cext_2740 N1.$308.met3 VSS.$378.met2 0.00651384f
Cext_2741 N1.$308.met3 VSS.$379.met2 0.101224f
Cext_2742 N1.$308.met3 VSS.$38.li1 0.00721477f
Cext_2743 N1.$308.met3 VSS.$380.met2 0.095307f
Cext_2744 N1.$308.met3 VSS.$389.met2 0.0466453f
Cext_2745 N1.$308.met3 VSS.$392.met2 0.00506315f
Cext_2746 N1.$308.met3 VSS.$415.met3 0.0264435f
Cext_2747 N1.$308.met3 VSS.$417.met3 0.0264435f
Cext_2748 N1.$308.met3 VSS.$6.li1 0.0106224f
Cext_2749 N1.$308.met3 VSS.$62.li1 0.00797786f
Cext_2750 N1.$308.met3 VSS.$67.li1 0.00308719f
Cext_2751 N1.$308.met3 VSS.P2.nsdm 0.00230306f
Cext_2752 N1.$308.met3 sky130_gnd 0.199342f
Cext_2753 N1.$309.met3 NB.$225.met1 0.00348909f
Cext_2754 N1.$309.met3 NB.$226.met1 0.00682707f
Cext_2755 N1.$309.met3 NB.$227.met1 0.0153561f
Cext_2756 N1.$309.met3 NB.$231.met1 0.00962622f
Cext_2757 N1.$309.met3 NB.$270.met2 0.00658933f
Cext_2758 N1.$309.met3 NB.$271.met2 0.00653075f
Cext_2759 N1.$309.met3 NB.$272.met2 0.0789298f
Cext_2760 N1.$309.met3 NB.$273.met2 0.0263992f
Cext_2761 N1.$309.met3 NB.$276.met3 0.0331053f
Cext_2762 N1.$309.met3 NB.$299.poly 0.00112371f
Cext_2763 N1.$309.met3 NB.$321.poly 0.0566428f
Cext_2764 N1.$309.met3 NB.$94.li1 0.00122562f
Cext_2765 N1.$309.met3 NB.$96.li1 0.00305658f
Cext_2766 N1.$309.met3 NB.P0.nsdm 0.00245103f
Cext_2767 N1.$309.met3 NB.P1.poly 0.104054f
Cext_2768 N1.$309.met3 PB.$5943.met3 0.0212214f
Cext_2769 N1.$309.met3 S 0.00303474f
Cext_2770 N1.$309.met3 S.$19.met1 0.00141579f
Cext_2771 N1.$309.met3 S.$25.met1 0.00352612f
Cext_2772 N1.$309.met3 S.$27.met1 0.00192509f
Cext_2773 N1.$309.met3 S.$30.met2 0.00255305f
Cext_2774 N1.$309.met3 S.$31.met2 0.00417828f
Cext_2775 N1.$309.met3 S.$35.met3 0.0228376f
Cext_2776 N1.$309.met3 S.P0.poly 0.00510247f
Cext_2777 N1.$309.met3 TAIL.$314.met1 0.00125799f
Cext_2778 N1.$309.met3 TAIL.$315.met1 0.00275003f
Cext_2779 N1.$309.met3 VREF.$103.met2 0.0250382f
Cext_2780 N1.$309.met3 VREF.$104.met2 0.0584183f
Cext_2781 N1.$309.met3 VREF.$107.met3 0.0627299f
Cext_2782 N1.$309.met3 VREF.$108.met3 0.0187126f
Cext_2783 N1.$309.met3 VREF.$109.met3 0.0671612f
Cext_2784 N1.$309.met3 VREF.$112.poly 0.00563319f
Cext_2785 N1.$309.met3 VREF.$54.li1 0.00156882f
Cext_2786 N1.$309.met3 VREF.$87.met1 0.0044168f
Cext_2787 N1.$309.met3 VREF.$90.met1 0.0011021f
Cext_2788 N1.$309.met3 VREF.$92.met1 0.00758435f
Cext_2789 N1.$309.met3 VSS 0.0647168f
Cext_2790 N1.$309.met3 VSS.$109.li1 0.0137559f
Cext_2791 N1.$309.met3 VSS.$113.li1 0.00212154f
Cext_2792 N1.$309.met3 VSS.$115.li1 0.00205613f
Cext_2793 N1.$309.met3 VSS.$276.met1 0.00127031f
Cext_2794 N1.$309.met3 VSS.$277.met1 0.00547755f
Cext_2795 N1.$309.met3 VSS.$278.met1 0.0118373f
Cext_2796 N1.$309.met3 VSS.$282.met1 0.00373362f
Cext_2797 N1.$309.met3 VSS.$302.met1 0.00133133f
Cext_2798 N1.$309.met3 VSS.$303.met1 0.00131875f
Cext_2799 N1.$309.met3 VSS.$389.met2 0.0346859f
Cext_2800 N1.$309.met3 VSS.$390.met2 0.00388617f
Cext_2801 N1.$309.met3 VSS.$392.met2 0.0252806f
Cext_2802 N1.$309.met3 VSS.$393.met2 0.0691292f
Cext_2803 N1.$309.met3 VSS.$396.met2 0.0429914f
Cext_2804 N1.$309.met3 VSS.$400.met2 0.0209781f
Cext_2805 N1.$309.met3 VSS.$401.met2 0.00233243f
Cext_2806 N1.$309.met3 VSS.$403.met2 0.0180049f
Cext_2807 N1.$309.met3 VSS.$405.met2 0.0396724f
Cext_2808 N1.$309.met3 VSS.$406.met2 0.014942f
Cext_2809 N1.$309.met3 VSS.$407.met2 0.0419726f
Cext_2810 N1.$309.met3 VSS.$408.met2 0.00560652f
Cext_2811 N1.$309.met3 VSS.$409.met2 0.00141102f
Cext_2812 N1.$309.met3 VSS.$422.met3 0.146972f
Cext_2813 N1.$309.met3 VSS.$424.met3 0.198439f
Cext_2814 N1.$309.met3 VSS.$426.met3 0.0688611f
Cext_2815 N1.$309.met3 VSS.$427.met3 0.0493333f
Cext_2816 N1.$309.met3 VSS.$428.met3 0.0102778f
Cext_2817 N1.$309.met3 VSS.$62.li1 0.00156527f
Cext_2818 N1.$309.met3 VSS.$71.li1 0.00305746f
Cext_2819 N1.$309.met3 VSS.$73.li1 0.00528434f
Cext_2820 N1.$309.met3 VSS.P3.nsdm 0.00137096f
Cext_2821 N1.$309.met3 sky130_gnd 0.357145f
Cext_2822 N1.$32.li1 TAIL.$32.li1 0.00111142f
Cext_2823 N1.$32.li1 VSS.$366.met2 0.00165239f
Cext_2824 N1.$32.li1 VSS.$6.li1 0.0133043f
Cext_2825 N1.$34.li1 TAIL.$34.li1 0.00111142f
Cext_2826 N1.$34.li1 VSS.$366.met2 0.00165239f
Cext_2827 N1.$34.li1 VSS.$6.li1 0.0133043f
Cext_2828 N1.$354.poly NB.$274.met2 0.00206962f
Cext_2829 N1.$354.poly PB.$11534.poly 0.00485491f
Cext_2830 N1.$354.poly PB.$5938.met3 0.0330532f
Cext_2831 N1.$354.poly PB.$5945.met3 0.0182579f
Cext_2832 N1.$354.poly VDD.$272.li1 0.0171124f
Cext_2833 N1.$354.poly VDD.$274.li1 0.0181146f
Cext_2834 N1.$354.poly VDD.$276.li1 0.00529676f
Cext_2835 N1.$354.poly VDD.$278.li1 0.00177361f
Cext_2836 N1.$354.poly VDD.$295.li1 0.00102006f
Cext_2837 N1.$354.poly VDD.$296.li1 0.00103443f
Cext_2838 N1.$354.poly VDD.$297.li1 0.00103443f
Cext_2839 N1.$354.poly VDD.$444.met1 0.00421947f
Cext_2840 N1.$354.poly VDD.$445.met1 0.0115057f
Cext_2841 N1.$354.poly VDD.$446.met1 0.00339922f
Cext_2842 N1.$354.poly VDD.$455.met1 0.0164878f
Cext_2843 N1.$354.poly VDD.$488.met2 0.00985665f
Cext_2844 N1.$354.poly VDD.$489.met2 0.00827726f
Cext_2845 N1.$354.poly VDD.$504.met3 0.0243034f
Cext_2846 N1.$354.poly VDD.$505.met3 0.00555126f
Cext_2847 N1.$354.poly VDD.$728.nwell 0.0191554f
Cext_2848 N1.$354.poly VDD.$750.nwell 0.151189f
Cext_2849 N1.$354.poly VDD.P1.nwell 0.164207f
Cext_2850 N1.$354.poly sky130_gnd 0.179927f
Cext_2851 N1.$355.poly PB.P1.poly 0.00501976f
Cext_2852 N1.$355.poly VDD.$286.li1 0.00177361f
Cext_2853 N1.$355.poly VDD.$288.li1 0.00529676f
Cext_2854 N1.$355.poly VDD.$290.li1 0.0181757f
Cext_2855 N1.$355.poly VDD.$292.li1 0.0172439f
Cext_2856 N1.$355.poly VDD.$301.li1 0.00103443f
Cext_2857 N1.$355.poly VDD.$302.li1 0.00103443f
Cext_2858 N1.$355.poly VDD.$303.li1 0.00103443f
Cext_2859 N1.$355.poly VDD.$442.met1 0.00179182f
Cext_2860 N1.$355.poly VDD.$452.met1 0.00342977f
Cext_2861 N1.$355.poly VDD.$453.met1 0.0151613f
Cext_2862 N1.$355.poly VDD.$454.met1 0.0135987f
Cext_2863 N1.$355.poly VDD.$455.met1 0.00149146f
Cext_2864 N1.$355.poly VDD.$487.met2 0.00739171f
Cext_2865 N1.$355.poly VDD.$489.met2 0.00478353f
Cext_2866 N1.$355.poly VDD.$504.met3 0.0283812f
Cext_2867 N1.$355.poly VDD.$505.met3 0.00793474f
Cext_2868 N1.$355.poly VDD.$739.nwell 0.0128107f
Cext_2869 N1.$355.poly VDD.$740.nwell 0.00803986f
Cext_2870 N1.$355.poly VDD.$750.nwell 0.147834f
Cext_2871 N1.$355.poly VDD.P1.nwell 0.158582f
Cext_2872 N1.$355.poly sky130_gnd 0.179927f
Cext_2873 N1.$36.li1 TAIL.$36.li1 0.00111142f
Cext_2874 N1.$36.li1 VSS.$366.met2 0.00165239f
Cext_2875 N1.$36.li1 VSS.$6.li1 0.0133043f
Cext_2876 N1.$376.poly PB.$5742.li1 0.0170878f
Cext_2877 N1.$376.poly PB.$5744.li1 0.018016f
Cext_2878 N1.$376.poly PB.$5746.li1 0.00529676f
Cext_2879 N1.$376.poly PB.$5748.li1 0.00177361f
Cext_2880 N1.$376.poly PB.$5904.met1 0.0134605f
Cext_2881 N1.$376.poly PB.$5905.met1 0.0149101f
Cext_2882 N1.$376.poly PB.$5906.met1 0.00320981f
Cext_2883 N1.$376.poly PB.$5931.met2 0.0264816f
Cext_2884 N1.$376.poly PB.$5945.met3 0.0787471f
Cext_2885 N1.$376.poly VDD.$306.li1 0.0172849f
Cext_2886 N1.$376.poly VDD.$308.li1 0.0181146f
Cext_2887 N1.$376.poly VDD.$310.li1 0.00529676f
Cext_2888 N1.$376.poly VDD.$312.li1 0.00177361f
Cext_2889 N1.$376.poly VDD.$331.li1 0.00103443f
Cext_2890 N1.$376.poly VDD.$459.met1 0.0141304f
Cext_2891 N1.$376.poly VDD.$460.met1 0.0150528f
Cext_2892 N1.$376.poly VDD.$461.met1 0.00339922f
Cext_2893 N1.$376.poly VDD.$491.met2 0.0013714f
Cext_2894 N1.$376.poly VDD.$492.met2 0.0237016f
Cext_2895 N1.$376.poly VDD.$494.met2 0.00752828f
Cext_2896 N1.$376.poly VDD.$495.met2 0.00141205f
Cext_2897 N1.$376.poly VDD.$505.met3 0.0207577f
Cext_2898 N1.$376.poly VDD.$506.met3 0.0150305f
Cext_2899 N1.$376.poly VDD.$750.nwell 0.0192187f
Cext_2900 N1.$376.poly VDD.$761.nwell 0.150771f
Cext_2901 N1.$376.poly VDD.P2.nwell 0.167275f
Cext_2902 N1.$376.poly VSS.$477.poly 0.00348501f
Cext_2903 N1.$376.poly sky130_gnd 0.179927f
Cext_2904 N1.$377.poly PB.$5756.li1 0.00177361f
Cext_2905 N1.$377.poly PB.$5758.li1 0.00529676f
Cext_2906 N1.$377.poly PB.$5760.li1 0.0194374f
Cext_2907 N1.$377.poly PB.$5762.li1 0.0172849f
Cext_2908 N1.$377.poly PB.$5912.met1 0.00342977f
Cext_2909 N1.$377.poly PB.$5913.met1 0.0151301f
Cext_2910 N1.$377.poly PB.$5914.met1 0.0136591f
Cext_2911 N1.$377.poly VDD.$320.li1 0.00177361f
Cext_2912 N1.$377.poly VDD.$322.li1 0.00529676f
Cext_2913 N1.$377.poly VDD.$324.li1 0.0181392f
Cext_2914 N1.$377.poly VDD.$326.li1 0.0172849f
Cext_2915 N1.$377.poly VDD.$335.li1 0.00103443f
Cext_2916 N1.$377.poly VDD.$336.li1 0.00103443f
Cext_2917 N1.$377.poly VDD.$337.li1 0.00103443f
Cext_2918 N1.$377.poly VDD.$467.met1 0.00342977f
Cext_2919 N1.$377.poly VDD.$468.met1 0.0151806f
Cext_2920 N1.$377.poly VDD.$469.met1 0.0137047f
Cext_2921 N1.$377.poly VDD.$505.met3 0.0204019f
Cext_2922 N1.$377.poly VDD.$506.met3 0.022374f
Cext_2923 N1.$377.poly VDD.$750.nwell 0.0191474f
Cext_2924 N1.$377.poly VDD.$761.nwell 0.147569f
Cext_2925 N1.$377.poly VDD.P2.nwell 0.158836f
Cext_2926 N1.$377.poly sky130_gnd 0.18181f
Cext_2927 N1.$38.li1 TAIL.$38.li1 0.00111142f
Cext_2928 N1.$38.li1 VSS.$366.met2 0.00165239f
Cext_2929 N1.$38.li1 VSS.$6.li1 0.0133043f
Cext_2930 N1.$4.li1 TAIL.$4.li1 0.00111041f
Cext_2931 N1.$4.li1 VSS.$366.met2 0.00165239f
Cext_2932 N1.$4.li1 VSS.$6.li1 0.0133043f
Cext_2933 N1.$40.li1 TAIL.$40.li1 0.00111142f
Cext_2934 N1.$40.li1 VSS.$366.met2 0.00186028f
Cext_2935 N1.$40.li1 VSS.$6.li1 0.0133043f
Cext_2936 N1.$42.li1 TAIL.$42.li1 0.00111142f
Cext_2937 N1.$42.li1 VSS.$366.met2 0.00173439f
Cext_2938 N1.$42.li1 VSS.$6.li1 0.0133043f
Cext_2939 N1.$44.li1 TAIL.$44.li1 0.00111142f
Cext_2940 N1.$44.li1 VSS.$366.met2 0.00132921f
Cext_2941 N1.$44.li1 VSS.$6.li1 0.0136663f
Cext_2942 N1.$46.li1 TAIL.$46.li1 0.00111142f
Cext_2943 N1.$46.li1 VSS.$220.met1 0.00165239f
Cext_2944 N1.$46.li1 VSS.$6.li1 0.0133043f
Cext_2945 N1.$48.li1 TAIL.$48.li1 0.00111142f
Cext_2946 N1.$48.li1 VSS.$220.met1 0.00165239f
Cext_2947 N1.$48.li1 VSS.$6.li1 0.0133043f
Cext_2948 N1.$50.li1 TAIL.$50.li1 0.00111142f
Cext_2949 N1.$50.li1 VSS.$220.met1 0.00165239f
Cext_2950 N1.$50.li1 VSS.$6.li1 0.0133043f
Cext_2951 N1.$52.li1 TAIL.$52.li1 0.00111142f
Cext_2952 N1.$52.li1 VSS.$220.met1 0.00165239f
Cext_2953 N1.$52.li1 VSS.$6.li1 0.0133043f
Cext_2954 N1.$54.li1 TAIL.$54.li1 0.00111142f
Cext_2955 N1.$54.li1 VSS.$220.met1 0.00165239f
Cext_2956 N1.$54.li1 VSS.$6.li1 0.0133043f
Cext_2957 N1.$56.li1 TAIL.$56.li1 0.00111142f
Cext_2958 N1.$56.li1 VSS.$220.met1 0.00165239f
Cext_2959 N1.$56.li1 VSS.$6.li1 0.0133043f
Cext_2960 N1.$58.li1 TAIL.$58.li1 0.00111142f
Cext_2961 N1.$58.li1 VSS.$220.met1 0.00165239f
Cext_2962 N1.$58.li1 VSS.$6.li1 0.0133043f
Cext_2963 N1.$6.li1 TAIL.$6.li1 0.00111142f
Cext_2964 N1.$6.li1 VSS.$366.met2 0.00165239f
Cext_2965 N1.$6.li1 VSS.$6.li1 0.0133043f
Cext_2966 N1.$60.li1 TAIL.$60.li1 0.00111142f
Cext_2967 N1.$60.li1 VSS.$220.met1 0.00165239f
Cext_2968 N1.$60.li1 VSS.$6.li1 0.0133043f
Cext_2969 N1.$62.li1 TAIL.$62.li1 0.00111142f
Cext_2970 N1.$62.li1 VSS.$220.met1 0.00165239f
Cext_2971 N1.$62.li1 VSS.$6.li1 0.0133043f
Cext_2972 N1.$64.li1 TAIL.$64.li1 0.00111142f
Cext_2973 N1.$64.li1 VSS.$220.met1 0.00165239f
Cext_2974 N1.$64.li1 VSS.$6.li1 0.0133043f
Cext_2975 N1.$66.li1 TAIL.$66.li1 0.00111142f
Cext_2976 N1.$66.li1 VSS.$220.met1 0.00165239f
Cext_2977 N1.$66.li1 VSS.$6.li1 0.0133043f
Cext_2978 N1.$68.li1 TAIL.$68.li1 0.00111142f
Cext_2979 N1.$68.li1 VSS.$220.met1 0.00165239f
Cext_2980 N1.$68.li1 VSS.$6.li1 0.0133043f
Cext_2981 N1.$70.li1 TAIL.$70.li1 0.00111142f
Cext_2982 N1.$70.li1 VSS.$220.met1 0.00165239f
Cext_2983 N1.$70.li1 VSS.$6.li1 0.0133043f
Cext_2984 N1.$72.li1 TAIL.$72.li1 0.00111142f
Cext_2985 N1.$72.li1 VSS.$220.met1 0.00165239f
Cext_2986 N1.$72.li1 VSS.$6.li1 0.0133043f
Cext_2987 N1.$74.li1 TAIL.$74.li1 0.00111142f
Cext_2988 N1.$74.li1 VSS.$220.met1 0.00165239f
Cext_2989 N1.$74.li1 VSS.$6.li1 0.0133043f
Cext_2990 N1.$76.li1 TAIL.$76.li1 0.00111142f
Cext_2991 N1.$76.li1 VSS.$220.met1 0.00165239f
Cext_2992 N1.$76.li1 VSS.$6.li1 0.0133043f
Cext_2993 N1.$78.li1 TAIL.$78.li1 0.00111142f
Cext_2994 N1.$78.li1 VSS.$220.met1 0.00165239f
Cext_2995 N1.$78.li1 VSS.$6.li1 0.0133043f
Cext_2996 N1.$8.li1 TAIL.$8.li1 0.00111142f
Cext_2997 N1.$8.li1 VSS.$366.met2 0.00165239f
Cext_2998 N1.$8.li1 VSS.$6.li1 0.0133043f
Cext_2999 N1.$80.li1 TAIL.$80.li1 0.00111142f
Cext_3000 N1.$80.li1 VSS.$220.met1 0.00165239f
Cext_3001 N1.$80.li1 VSS.$6.li1 0.0133043f
Cext_3002 N1.$82.li1 TAIL.$82.li1 0.00111142f
Cext_3003 N1.$82.li1 VSS.$220.met1 0.00165239f
Cext_3004 N1.$82.li1 VSS.$6.li1 0.0133043f
Cext_3005 N1.$84.li1 TAIL.$84.li1 0.00111142f
Cext_3006 N1.$84.li1 VSS.$220.met1 0.00165239f
Cext_3007 N1.$84.li1 VSS.$6.li1 0.0133043f
Cext_3008 N1.$86.li1 TAIL.$86.li1 0.00106309f
Cext_3009 N1.$86.li1 VSS.$220.met1 0.00149174f
Cext_3010 N1.$86.li1 VSS.$6.li1 0.01275f
Cext_3011 N1.$86.li1 sky130_gnd 0.00599931f
Cext_3012 N1.$88.li1 VDD.$489.met2 0.00187809f
Cext_3013 N1.$88.li1 VDD.$728.nwell 0.00263027f
Cext_3014 N1.$88.li1 VDD.P1.nwell 0.00130102f
Cext_3015 N1.$88.li1 sky130_gnd 0.0153005f
Cext_3016 N1.$90.li1 VDD.$739.nwell 0.00106543f
Cext_3017 N1.$90.li1 VDD.$740.nwell 0.00214395f
Cext_3018 N1.$90.li1 VDD.P1.nwell 0.00103409f
Cext_3019 N1.$90.li1 sky130_gnd 0.0153005f
Cext_3020 N1.$92.li1 VDD.P1.nwell 0.00144114f
Cext_3021 N1.$92.li1 sky130_gnd 0.0125941f
Cext_3022 N1.$94.li1 VDD.P1.nwell 0.00144114f
Cext_3023 N1.$94.li1 sky130_gnd 0.0125941f
Cext_3024 N1.$96.li1 VDD.P1.nwell 0.00144114f
Cext_3025 N1.$96.li1 sky130_gnd 0.0125941f
Cext_3026 N1.$98.li1 VDD.P1.nwell 0.00144114f
Cext_3027 N1.$98.li1 sky130_gnd 0.0125941f
Cext_3028 N1.P0.nsdm TAIL.$340.met3 0.00817156f
Cext_3029 N1.P0.nsdm VSS.$6.li1 0.0351912f
Cext_3030 N1.P0.poly PB.$11534.poly 0.00136978f
Cext_3031 N1.P0.poly VDD.$276.li1 0.0128424f
Cext_3032 N1.P0.poly VDD.$278.li1 0.0163656f
Cext_3033 N1.P0.poly VDD.$280.li1 0.0171799f
Cext_3034 N1.P0.poly VDD.$282.li1 0.0181392f
Cext_3035 N1.P0.poly VDD.$284.li1 0.017184f
Cext_3036 N1.P0.poly VDD.$286.li1 0.0164021f
Cext_3037 N1.P0.poly VDD.$288.li1 0.0128789f
Cext_3038 N1.P0.poly VDD.$305.li1 0.00237654f
Cext_3039 N1.P0.poly VDD.$446.met1 0.0117003f
Cext_3040 N1.P0.poly VDD.$447.met1 0.0149101f
Cext_3041 N1.P0.poly VDD.$448.met1 0.0150111f
Cext_3042 N1.P0.poly VDD.$449.met1 0.0151301f
Cext_3043 N1.P0.poly VDD.$450.met1 0.0150146f
Cext_3044 N1.P0.poly VDD.$451.met1 0.0149414f
Cext_3045 N1.P0.poly VDD.$452.met1 0.0117316f
Cext_3046 N1.P0.poly VDD.$455.met1 0.00251083f
Cext_3047 N1.P0.poly VDD.$489.met2 0.016271f
Cext_3048 N1.P0.poly VDD.$504.met3 0.096159f
Cext_3049 N1.P0.psdm VDD.$505.met3 0.00120433f
Cext_3050 N1.P1.poly PB.$5746.li1 0.0128424f
Cext_3051 N1.P1.poly PB.$5748.li1 0.0163656f
Cext_3052 N1.P1.poly PB.$5750.li1 0.0171799f
Cext_3053 N1.P1.poly PB.$5752.li1 0.0179914f
Cext_3054 N1.P1.poly PB.$5754.li1 0.0171799f
Cext_3055 N1.P1.poly PB.$5756.li1 0.0163656f
Cext_3056 N1.P1.poly PB.$5758.li1 0.0128424f
Cext_3057 N1.P1.poly PB.$5906.met1 0.0117003f
Cext_3058 N1.P1.poly PB.$5907.met1 0.0149101f
Cext_3059 N1.P1.poly PB.$5908.met1 0.0149101f
Cext_3060 N1.P1.poly PB.$5909.met1 0.0149223f
Cext_3061 N1.P1.poly PB.$5910.met1 0.0150111f
Cext_3062 N1.P1.poly PB.$5911.met1 0.0149101f
Cext_3063 N1.P1.poly PB.$5912.met1 0.0117003f
Cext_3064 N1.P1.poly VDD.$310.li1 0.0128424f
Cext_3065 N1.P1.poly VDD.$312.li1 0.0163656f
Cext_3066 N1.P1.poly VDD.$314.li1 0.0171799f
Cext_3067 N1.P1.poly VDD.$316.li1 0.0179914f
Cext_3068 N1.P1.poly VDD.$318.li1 0.0171799f
Cext_3069 N1.P1.poly VDD.$320.li1 0.0163656f
Cext_3070 N1.P1.poly VDD.$322.li1 0.0128424f
Cext_3071 N1.P1.poly VDD.$339.li1 0.00237654f
Cext_3072 N1.P1.poly VDD.$461.met1 0.0117003f
Cext_3073 N1.P1.poly VDD.$462.met1 0.0149101f
Cext_3074 N1.P1.poly VDD.$463.met1 0.0149101f
Cext_3075 N1.P1.poly VDD.$464.met1 0.0151874f
Cext_3076 N1.P1.poly VDD.$465.met1 0.0150167f
Cext_3077 N1.P1.poly VDD.$466.met1 0.0149606f
Cext_3078 N1.P1.poly VDD.$467.met1 0.0117508f
Cext_3079 N1.P1.poly VDD.$490.met2 0.00116864f
Cext_3080 N1.P1.poly VDD.$491.met2 0.0509306f
Cext_3081 N1.P1.poly VDD.$493.met2 0.0212611f
Cext_3082 N1.P1.poly VDD.$494.met2 0.0172052f
Cext_3083 N1.P1.poly VDD.$505.met3 0.0751267f
Cext_3084 N1.P1.poly VDD.$506.met3 0.040002f
Cext_3085 NB PB.$5938.met3 0.0315628f
Cext_3086 NB VDD.$248.li1 0.00366954f
Cext_3087 NB VDD.$249.li1 0.00104134f
Cext_3088 NB VDD.$251.li1 0.00788921f
Cext_3089 NB VDD.$487.met2 0.00519417f
Cext_3090 NB VDD.$488.met2 0.00352113f
Cext_3091 NB VDD.$504.met3 0.00359682f
Cext_3092 NB VDD.$728.nwell 0.0044828f
Cext_3093 NB VDD.$731.nwell 0.0016485f
Cext_3094 NB sky130_gnd 0.0184073f
Cext_3095 NB.$0.li1 VSS.$379.met2 0.0015527f
Cext_3096 NB.$0.li1 sky130_gnd 0.0191686f
Cext_3097 NB.$10.li1 sky130_gnd 0.0140353f
Cext_3098 NB.$100.li1 VSS.$109.li1 0.0149932f
Cext_3099 NB.$100.li1 VSS.$77.li1 0.00107494f
Cext_3100 NB.$102.li1 VSS.$109.li1 0.0149932f
Cext_3101 NB.$102.li1 VSS.$79.li1 0.00107494f
Cext_3102 NB.$104.li1 VSS.$109.li1 0.0149932f
Cext_3103 NB.$104.li1 VSS.$81.li1 0.00107494f
Cext_3104 NB.$106.li1 VSS.$109.li1 0.0149648f
Cext_3105 NB.$106.li1 VSS.$83.li1 0.00107494f
Cext_3106 NB.$108.li1 VSS.$109.li1 0.0148879f
Cext_3107 NB.$108.li1 VSS.$85.li1 0.00107494f
Cext_3108 NB.$110.li1 VSS.$109.li1 0.0148879f
Cext_3109 NB.$110.li1 VSS.$87.li1 0.00107494f
Cext_3110 NB.$112.li1 VREF.$107.met3 0.00339512f
Cext_3111 NB.$112.li1 VSS.$109.li1 0.0149567f
Cext_3112 NB.$112.li1 VSS.$89.li1 0.00107494f
Cext_3113 NB.$114.li1 VSS.$109.li1 0.0149841f
Cext_3114 NB.$114.li1 VSS.$91.li1 0.00107494f
Cext_3115 NB.$116.li1 VSS.$109.li1 0.0149932f
Cext_3116 NB.$116.li1 VSS.$93.li1 0.00107494f
Cext_3117 NB.$118.li1 VSS.$109.li1 0.0149932f
Cext_3118 NB.$118.li1 VSS.$95.li1 0.00107494f
Cext_3119 NB.$12.li1 VSS.$380.met2 0.00119718f
Cext_3120 NB.$12.li1 sky130_gnd 0.0140353f
Cext_3121 NB.$120.li1 VSS.$109.li1 0.0149932f
Cext_3122 NB.$120.li1 VSS.$97.li1 0.00107494f
Cext_3123 NB.$122.li1 VSS.$100.li1 0.00107494f
Cext_3124 NB.$122.li1 VSS.$109.li1 0.0149932f
Cext_3125 NB.$124.li1 VSS.$101.li1 0.00107494f
Cext_3126 NB.$124.li1 VSS.$109.li1 0.0149932f
Cext_3127 NB.$126.li1 VSS.$103.li1 0.00107494f
Cext_3128 NB.$126.li1 VSS.$109.li1 0.0149932f
Cext_3129 NB.$128.li1 VSS.$105.li1 0.00107494f
Cext_3130 NB.$128.li1 VSS.$109.li1 0.0149932f
Cext_3131 NB.$130.li1 VSS.$107.li1 0.00103015f
Cext_3132 NB.$130.li1 VSS.$109.li1 0.0142747f
Cext_3133 NB.$130.li1 sky130_gnd 0.00671871f
Cext_3134 NB.$132.li1 PB.$11534.poly 0.0173813f
Cext_3135 NB.$132.li1 PB.$5938.met3 0.00110811f
Cext_3136 NB.$132.li1 VDD.$204.li1 0.00103015f
Cext_3137 NB.$132.li1 VDD.$248.li1 0.0160812f
Cext_3138 NB.$132.li1 VDD.$728.nwell 0.00236608f
Cext_3139 NB.$132.li1 sky130_gnd 0.00435263f
Cext_3140 NB.$134.li1 PB.$11534.poly 0.018261f
Cext_3141 NB.$134.li1 VDD.$206.li1 0.00107494f
Cext_3142 NB.$134.li1 VDD.$249.li1 0.0166248f
Cext_3143 NB.$136.li1 PB.$11534.poly 0.0183244f
Cext_3144 NB.$136.li1 VDD.$208.li1 0.00107494f
Cext_3145 NB.$136.li1 VDD.$250.li1 0.0170045f
Cext_3146 NB.$138.li1 PB.$11534.poly 0.0183543f
Cext_3147 NB.$138.li1 VDD.$210.li1 0.00107494f
Cext_3148 NB.$138.li1 VDD.$251.li1 0.0168983f
Cext_3149 NB.$138.li1 VDD.$503.met3 0.00413406f
Cext_3150 NB.$14.li1 sky130_gnd 0.0140353f
Cext_3151 NB.$140.li1 PB.$11534.poly 0.0173016f
Cext_3152 NB.$140.li1 PB.P1.poly 0.00102285f
Cext_3153 NB.$140.li1 VDD.$212.li1 0.00107494f
Cext_3154 NB.$140.li1 VDD.$252.li1 0.0170339f
Cext_3155 NB.$142.li1 PB.$11534.poly 0.00177361f
Cext_3156 NB.$142.li1 PB.P1.poly 0.0165807f
Cext_3157 NB.$142.li1 VDD.$214.li1 0.00107494f
Cext_3158 NB.$142.li1 VDD.$253.li1 0.0166794f
Cext_3159 NB.$144.li1 PB.P1.poly 0.018004f
Cext_3160 NB.$144.li1 VDD.$216.li1 0.00107494f
Cext_3161 NB.$144.li1 VDD.$254.li1 0.0166794f
Cext_3162 NB.$146.li1 PB.P1.poly 0.0183543f
Cext_3163 NB.$146.li1 VDD.$218.li1 0.00107494f
Cext_3164 NB.$146.li1 VDD.$255.li1 0.0166794f
Cext_3165 NB.$148.li1 PB.P1.poly 0.0183543f
Cext_3166 NB.$148.li1 VDD.$220.li1 0.00107494f
Cext_3167 NB.$148.li1 VDD.$256.li1 0.0166794f
Cext_3168 NB.$150.li1 PB.P1.poly 0.0183543f
Cext_3169 NB.$150.li1 VDD.$222.li1 0.00107494f
Cext_3170 NB.$150.li1 VDD.$257.li1 0.0166794f
Cext_3171 NB.$152.li1 PB.P1.poly 0.018149f
Cext_3172 NB.$152.li1 VDD.$224.li1 0.00107494f
Cext_3173 NB.$152.li1 VDD.$258.li1 0.015132f
Cext_3174 NB.$152.li1 VDD.$270.li1 0.0012197f
Cext_3175 NB.$154.li1 PB.P1.poly 0.0182199f
Cext_3176 NB.$154.li1 VDD.$226.li1 0.00107494f
Cext_3177 NB.$154.li1 VDD.$259.li1 0.0151596f
Cext_3178 NB.$154.li1 VDD.$270.li1 0.0012197f
Cext_3179 NB.$156.li1 PB.P1.poly 0.0182558f
Cext_3180 NB.$156.li1 VDD.$228.li1 0.00107494f
Cext_3181 NB.$156.li1 VDD.$260.li1 0.0165927f
Cext_3182 NB.$158.li1 PB.P1.poly 0.0183543f
Cext_3183 NB.$158.li1 VDD.$230.li1 0.00107494f
Cext_3184 NB.$158.li1 VDD.$261.li1 0.0166794f
Cext_3185 NB.$16.li1 VSS.$380.met2 0.00245599f
Cext_3186 NB.$16.li1 sky130_gnd 0.0140353f
Cext_3187 NB.$160.li1 PB.P1.poly 0.0183543f
Cext_3188 NB.$160.li1 VDD.$232.li1 0.00107494f
Cext_3189 NB.$160.li1 VDD.$262.li1 0.0166794f
Cext_3190 NB.$162.li1 PB.P1.poly 0.018004f
Cext_3191 NB.$162.li1 VDD.$234.li1 0.00107494f
Cext_3192 NB.$162.li1 VDD.$263.li1 0.0166794f
Cext_3193 NB.$164.li1 PB.$11535.poly 0.00177361f
Cext_3194 NB.$164.li1 PB.P1.poly 0.0165807f
Cext_3195 NB.$164.li1 VDD.$236.li1 0.00107494f
Cext_3196 NB.$164.li1 VDD.$264.li1 0.0166794f
Cext_3197 NB.$166.li1 PB.$11535.poly 0.0173315f
Cext_3198 NB.$166.li1 PB.P1.poly 0.00102285f
Cext_3199 NB.$166.li1 VDD.$238.li1 0.00107494f
Cext_3200 NB.$166.li1 VDD.$265.li1 0.0166794f
Cext_3201 NB.$168.li1 PB.$11535.poly 0.0183543f
Cext_3202 NB.$168.li1 VDD.$240.li1 0.00107494f
Cext_3203 NB.$168.li1 VDD.$266.li1 0.0166794f
Cext_3204 NB.$170.li1 PB.$11535.poly 0.018968f
Cext_3205 NB.$170.li1 VDD.$242.li1 0.00107494f
Cext_3206 NB.$170.li1 VDD.$267.li1 0.0166794f
Cext_3207 NB.$172.li1 PB.$11535.poly 0.0183543f
Cext_3208 NB.$172.li1 VDD.$244.li1 0.00107494f
Cext_3209 NB.$172.li1 VDD.$268.li1 0.0166794f
Cext_3210 NB.$174.li1 PB.$11535.poly 0.0174791f
Cext_3211 NB.$174.li1 VDD.$246.li1 0.00103015f
Cext_3212 NB.$174.li1 VDD.$269.li1 0.0158673f
Cext_3213 NB.$174.li1 VDD.$749.nwell 0.00236608f
Cext_3214 NB.$174.li1 sky130_gnd 0.00435263f
Cext_3215 NB.$176.met1 PB.$5936.met3 0.00136745f
Cext_3216 NB.$176.met1 TAIL.$341.met3 0.00164839f
Cext_3217 NB.$176.met1 VSS.$378.met2 0.00313864f
Cext_3218 NB.$176.met1 VSS.$379.met2 0.00115484f
Cext_3219 NB.$176.met1 sky130_gnd 0.0200593f
Cext_3220 NB.$177.met1 sky130_gnd 0.0192484f
Cext_3221 NB.$178.met1 PB.$5936.met3 0.00145444f
Cext_3222 NB.$178.met1 TAIL.$341.met3 0.00172521f
Cext_3223 NB.$178.met1 VSS.$378.met2 0.00429707f
Cext_3224 NB.$178.met1 sky130_gnd 0.0143234f
Cext_3225 NB.$179.met1 sky130_gnd 0.0143234f
Cext_3226 NB.$18.li1 sky130_gnd 0.0140353f
Cext_3227 NB.$180.met1 VSS.$378.met2 0.00153632f
Cext_3228 NB.$180.met1 sky130_gnd 0.00176201f
Cext_3229 NB.$181.met1 sky130_gnd 0.0143234f
Cext_3230 NB.$182.met1 sky130_gnd 0.0209931f
Cext_3231 NB.$183.met1 VSS.$380.met2 0.00386477f
Cext_3232 NB.$183.met1 sky130_gnd 0.0129706f
Cext_3233 NB.$184.met1 sky130_gnd 0.0143234f
Cext_3234 NB.$185.met1 VSS.$380.met2 0.0193044f
Cext_3235 NB.$185.met1 sky130_gnd 0.0143234f
Cext_3236 NB.$186.met1 sky130_gnd 0.0143234f
Cext_3237 NB.$187.met1 VSS.$380.met2 0.0417521f
Cext_3238 NB.$187.met1 sky130_gnd 0.0143234f
Cext_3239 NB.$188.met1 VREF.$100.met2 0.0034797f
Cext_3240 NB.$188.met1 sky130_gnd 0.0143234f
Cext_3241 NB.$189.met1 VSS.$380.met2 0.00429707f
Cext_3242 NB.$189.met1 sky130_gnd 0.0143234f
Cext_3243 NB.$190.met1 sky130_gnd 0.0143234f
Cext_3244 NB.$191.met1 VSS.$380.met2 0.00497089f
Cext_3245 NB.$191.met1 sky130_gnd 0.0143234f
Cext_3246 NB.$192.met1 sky130_gnd 0.0143234f
Cext_3247 NB.$193.met1 VSS.$380.met2 0.0186457f
Cext_3248 NB.$193.met1 sky130_gnd 0.0143234f
Cext_3249 NB.$194.met1 sky130_gnd 0.0143234f
Cext_3250 NB.$195.met1 TAIL.$341.met3 0.00145184f
Cext_3251 NB.$195.met1 sky130_gnd 0.0143234f
Cext_3252 NB.$196.met1 sky130_gnd 0.0143234f
Cext_3253 NB.$197.met1 TAIL 0.0016122f
Cext_3254 NB.$197.met1 TAIL.$310.met1 0.00168306f
Cext_3255 NB.$197.met1 sky130_gnd 0.0200593f
Cext_3256 NB.$198.met1 sky130_gnd 0.0200593f
Cext_3257 NB.$199.met1 VSS.$422.met3 0.00131069f
Cext_3258 NB.$199.met1 sky130_gnd 0.0200593f
Cext_3259 NB.$2.li1 sky130_gnd 0.0186917f
Cext_3260 NB.$20.li1 VSS.$380.met2 0.0111278f
Cext_3261 NB.$20.li1 sky130_gnd 0.0140353f
Cext_3262 NB.$200.met1 sky130_gnd 0.0200593f
Cext_3263 NB.$201.met1 sky130_gnd 0.00712737f
Cext_3264 NB.$202.met1 sky130_gnd 0.0143234f
Cext_3265 NB.$203.met1 sky130_gnd 0.0170843f
Cext_3266 NB.$204.met1 sky130_gnd 0.0115705f
Cext_3267 NB.$205.met1 sky130_gnd 0.0143234f
Cext_3268 NB.$206.met1 PB.$5942.met3 0.00122086f
Cext_3269 NB.$206.met1 VSS.$422.met3 0.00184025f
Cext_3270 NB.$206.met1 sky130_gnd 0.0143234f
Cext_3271 NB.$207.met1 sky130_gnd 0.0143234f
Cext_3272 NB.$208.met1 PB.$5942.met3 0.00171694f
Cext_3273 NB.$208.met1 VSS.$422.met3 0.00221195f
Cext_3274 NB.$208.met1 sky130_gnd 0.0143234f
Cext_3275 NB.$209.met1 VREF.$100.met2 0.0010431f
Cext_3276 NB.$209.met1 sky130_gnd 0.0143234f
Cext_3277 NB.$210.met1 PB.$5942.met3 0.00157579f
Cext_3278 NB.$210.met1 VSS.$422.met3 0.00192031f
Cext_3279 NB.$210.met1 sky130_gnd 0.0143234f
Cext_3280 NB.$211.met1 sky130_gnd 0.0143234f
Cext_3281 NB.$212.met1 PB.$5942.met3 0.00158133f
Cext_3282 NB.$212.met1 VSS.$422.met3 0.00193175f
Cext_3283 NB.$212.met1 sky130_gnd 0.0143234f
Cext_3284 NB.$213.met1 sky130_gnd 0.0143234f
Cext_3285 NB.$214.met1 PB.$5942.met3 0.00171694f
Cext_3286 NB.$214.met1 VSS.$422.met3 0.00221195f
Cext_3287 NB.$214.met1 sky130_gnd 0.0143234f
Cext_3288 NB.$215.met1 sky130_gnd 0.0143234f
Cext_3289 NB.$216.met1 PB.$5942.met3 0.00153151f
Cext_3290 NB.$216.met1 VSS.$422.met3 0.00140376f
Cext_3291 NB.$216.met1 sky130_gnd 0.0143234f
Cext_3292 NB.$217.met1 sky130_gnd 0.0143234f
Cext_3293 NB.$218.met1 PB.$5942.met3 0.00162561f
Cext_3294 NB.$218.met1 VSS.$424.met3 0.00190934f
Cext_3295 NB.$218.met1 sky130_gnd 0.0143234f
Cext_3296 NB.$219.met1 sky130_gnd 0.0143234f
Cext_3297 NB.$22.li1 sky130_gnd 0.0140353f
Cext_3298 NB.$220.met1 PB.$5942.met3 0.00145463f
Cext_3299 NB.$220.met1 VREF.$86.met1 0.00154759f
Cext_3300 NB.$220.met1 VSS.$424.met3 0.00181193f
Cext_3301 NB.$220.met1 sky130_gnd 0.0200413f
Cext_3302 NB.$221.met1 sky130_gnd 0.0220639f
Cext_3303 NB.$222.met1 VSS.$275.met1 0.00189601f
Cext_3304 NB.$222.met1 sky130_gnd 0.00119546f
Cext_3305 NB.$223.met1 VSS 0.00129226f
Cext_3306 NB.$223.met1 VSS.$111.li1 0.00421764f
Cext_3307 NB.$223.met1 VSS.$274.met1 0.0015475f
Cext_3308 NB.$223.met1 VSS.$301.met1 0.00163907f
Cext_3309 NB.$223.met1 VSS.$424.met3 0.00364104f
Cext_3310 NB.$223.met1 sky130_gnd 0.0163561f
Cext_3311 NB.$224.met1 VSS 0.00158611f
Cext_3312 NB.$224.met1 VSS.$111.li1 0.00118262f
Cext_3313 NB.$224.met1 VSS.$113.li1 0.00323978f
Cext_3314 NB.$224.met1 VSS.$300.met1 0.00246154f
Cext_3315 NB.$224.met1 VSS.$424.met3 0.00740771f
Cext_3316 NB.$224.met1 sky130_gnd 0.00755113f
Cext_3317 NB.$225.met1 S.$23.met1 0.000217678f
Cext_3318 NB.$225.met1 VSS 0.00164554f
Cext_3319 NB.$225.met1 VSS.$113.li1 0.00493906f
Cext_3320 NB.$225.met1 VSS.$276.met1 0.00175381f
Cext_3321 NB.$225.met1 VSS.$424.met3 0.00423446f
Cext_3322 NB.$225.met1 sky130_gnd 0.00924399f
Cext_3323 NB.$226.met1 VREF.$87.met1 0.00154268f
Cext_3324 NB.$226.met1 VSS 0.00183271f
Cext_3325 NB.$226.met1 VSS.$109.li1 0.00168904f
Cext_3326 NB.$226.met1 VSS.$113.li1 0.0027765f
Cext_3327 NB.$226.met1 VSS.$277.met1 0.00183333f
Cext_3328 NB.$226.met1 sky130_gnd 0.00910701f
Cext_3329 NB.$227.met1 VSS 0.00136345f
Cext_3330 NB.$227.met1 VSS.$109.li1 0.00554701f
Cext_3331 NB.$227.met1 VSS.$278.met1 0.00183333f
Cext_3332 NB.$227.met1 sky130_gnd 0.0117374f
Cext_3333 NB.$228.met1 VSS.$109.li1 0.00658546f
Cext_3334 NB.$228.met1 VSS.$279.met1 0.00183333f
Cext_3335 NB.$228.met1 sky130_gnd 0.0119209f
Cext_3336 NB.$229.met1 VSS.$109.li1 0.0065542f
Cext_3337 NB.$229.met1 VSS.$280.met1 0.00183333f
Cext_3338 NB.$229.met1 VSS.$396.met2 0.00894799f
Cext_3339 NB.$229.met1 sky130_gnd 0.0119209f
Cext_3340 NB.$230.met1 VSS.$109.li1 0.0065542f
Cext_3341 NB.$230.met1 VSS.$281.met1 0.00183333f
Cext_3342 NB.$230.met1 VSS.$396.met2 0.0140209f
Cext_3343 NB.$230.met1 sky130_gnd 0.0119209f
Cext_3344 NB.$231.met1 VREF.$109.met3 0.00977123f
Cext_3345 NB.$231.met1 VSS.$109.li1 0.0065542f
Cext_3346 NB.$231.met1 VSS.$282.met1 0.00183333f
Cext_3347 NB.$231.met1 VSS.$396.met2 0.0114454f
Cext_3348 NB.$231.met1 sky130_gnd 0.0119209f
Cext_3349 NB.$232.met1 VSS.$109.li1 0.0065542f
Cext_3350 NB.$232.met1 VSS.$283.met1 0.00183333f
Cext_3351 NB.$232.met1 VSS.$396.met2 0.0114211f
Cext_3352 NB.$232.met1 sky130_gnd 0.0119209f
Cext_3353 NB.$233.met1 VSS.$109.li1 0.00778375f
Cext_3354 NB.$233.met1 VSS.$284.met1 0.00183333f
Cext_3355 NB.$233.met1 VSS.$296.met1 0.00395506f
Cext_3356 NB.$233.met1 VSS.$396.met2 0.0117639f
Cext_3357 NB.$233.met1 sky130_gnd 0.00662272f
Cext_3358 NB.$234.met1 VREF.$109.met3 0.00108153f
Cext_3359 NB.$234.met1 VSS.$109.li1 0.00766499f
Cext_3360 NB.$234.met1 VSS.$285.met1 0.00183333f
Cext_3361 NB.$234.met1 VSS.$296.met1 0.00395506f
Cext_3362 NB.$234.met1 VSS.$396.met2 0.00669092f
Cext_3363 NB.$234.met1 sky130_gnd 0.00662272f
Cext_3364 NB.$235.met1 VREF.$107.met3 0.00593463f
Cext_3365 NB.$235.met1 VREF.$109.met3 0.0118028f
Cext_3366 NB.$235.met1 VSS.$109.li1 0.0065542f
Cext_3367 NB.$235.met1 VSS.$286.met1 0.00183333f
Cext_3368 NB.$235.met1 sky130_gnd 0.0119209f
Cext_3369 NB.$236.met1 VREF.$109.met3 0.00236332f
Cext_3370 NB.$236.met1 VSS.$109.li1 0.00651167f
Cext_3371 NB.$236.met1 VSS.$287.met1 0.00183333f
Cext_3372 NB.$236.met1 sky130_gnd 0.0119209f
Cext_3373 NB.$237.met1 VSS.$109.li1 0.00658546f
Cext_3374 NB.$237.met1 VSS.$288.met1 0.00183333f
Cext_3375 NB.$237.met1 sky130_gnd 0.0119209f
Cext_3376 NB.$238.met1 VSS.$109.li1 0.00658546f
Cext_3377 NB.$238.met1 VSS.$289.met1 0.00183333f
Cext_3378 NB.$238.met1 sky130_gnd 0.0119209f
Cext_3379 NB.$239.met1 VSS.$109.li1 0.00658546f
Cext_3380 NB.$239.met1 VSS.$290.met1 0.00183333f
Cext_3381 NB.$239.met1 sky130_gnd 0.0119209f
Cext_3382 NB.$24.li1 VSS.$380.met2 0.00119718f
Cext_3383 NB.$24.li1 sky130_gnd 0.0140353f
Cext_3384 NB.$240.met1 VREF.$109.met3 0.0103423f
Cext_3385 NB.$240.met1 VSS.$109.li1 0.00658546f
Cext_3386 NB.$240.met1 VSS.$291.met1 0.00183333f
Cext_3387 NB.$240.met1 sky130_gnd 0.0119209f
Cext_3388 NB.$241.met1 VSS.$109.li1 0.00658546f
Cext_3389 NB.$241.met1 VSS.$292.met1 0.00183333f
Cext_3390 NB.$241.met1 sky130_gnd 0.0119209f
Cext_3391 NB.$242.met1 VSS.$109.li1 0.00658546f
Cext_3392 NB.$242.met1 VSS.$293.met1 0.00183333f
Cext_3393 NB.$242.met1 sky130_gnd 0.0119209f
Cext_3394 NB.$243.met1 VSS.$109.li1 0.00658546f
Cext_3395 NB.$243.met1 VSS.$294.met1 0.00183333f
Cext_3396 NB.$243.met1 sky130_gnd 0.0119209f
Cext_3397 NB.$244.met1 VSS.$109.li1 0.00594521f
Cext_3398 NB.$244.met1 VSS.$295.met1 0.00165509f
Cext_3399 NB.$244.met1 sky130_gnd 0.0198229f
Cext_3400 NB.$245.met1 PB.$11534.poly 0.0135733f
Cext_3401 NB.$245.met1 PB.$5938.met3 0.00202998f
Cext_3402 NB.$245.met1 VDD.$420.met1 0.00165509f
Cext_3403 NB.$245.met1 VDD.$728.nwell 0.0029674f
Cext_3404 NB.$245.met1 sky130_gnd 0.00770357f
Cext_3405 NB.$246.met1 PB.$11534.poly 0.0152051f
Cext_3406 NB.$246.met1 PB.$5938.met3 0.00284964f
Cext_3407 NB.$246.met1 VDD.$249.li1 0.00519948f
Cext_3408 NB.$246.met1 VDD.$421.met1 0.00183333f
Cext_3409 NB.$246.met1 VDD.$445.met1 0.0019369f
Cext_3410 NB.$246.met1 VDD.$729.nwell 0.00166291f
Cext_3411 NB.$246.met1 sky130_gnd 0.00554735f
Cext_3412 NB.$247.met1 PB.$11534.poly 0.0153251f
Cext_3413 NB.$247.met1 PB.$5938.met3 0.00355899f
Cext_3414 NB.$247.met1 VDD.$250.li1 0.00668465f
Cext_3415 NB.$247.met1 VDD.$422.met1 0.00183333f
Cext_3416 NB.$247.met1 VDD.$446.met1 0.00225301f
Cext_3417 NB.$247.met1 VDD.$504.met3 0.00524958f
Cext_3418 NB.$247.met1 VDD.$730.nwell 0.0019254f
Cext_3419 NB.$247.met1 sky130_gnd 0.00649879f
Cext_3420 NB.$248.met1 PB.$11534.poly 0.0153921f
Cext_3421 NB.$248.met1 VDD.$251.li1 0.00639308f
Cext_3422 NB.$248.met1 VDD.$423.met1 0.00183333f
Cext_3423 NB.$248.met1 VDD.$447.met1 0.00225301f
Cext_3424 NB.$248.met1 VDD.$503.met3 0.00819439f
Cext_3425 NB.$248.met1 VDD.$504.met3 0.0114572f
Cext_3426 NB.$248.met1 VDD.$731.nwell 0.00158074f
Cext_3427 NB.$248.met1 sky130_gnd 0.00649879f
Cext_3428 NB.$249.met1 PB.$11534.poly 0.0143933f
Cext_3429 NB.$249.met1 VDD.$252.li1 0.0070545f
Cext_3430 NB.$249.met1 VDD.$424.met1 0.00183333f
Cext_3431 NB.$249.met1 VDD.$448.met1 0.00225301f
Cext_3432 NB.$249.met1 VDD.$504.met3 0.00169059f
Cext_3433 NB.$249.met1 VDD.$732.nwell 0.00158074f
Cext_3434 NB.$249.met1 sky130_gnd 0.00649879f
Cext_3435 NB.$250.met1 PB.P1.poly 0.0151721f
Cext_3436 NB.$250.met1 VDD.$253.li1 0.00692994f
Cext_3437 NB.$250.met1 VDD.$425.met1 0.00183333f
Cext_3438 NB.$250.met1 VDD.$449.met1 0.00225301f
Cext_3439 NB.$250.met1 VDD.$487.met2 0.00190062f
Cext_3440 NB.$250.met1 VDD.$489.met2 0.00361696f
Cext_3441 NB.$250.met1 VDD.$733.nwell 0.00158074f
Cext_3442 NB.$250.met1 sky130_gnd 0.00649879f
Cext_3443 NB.$251.met1 PB.P1.poly 0.0153486f
Cext_3444 NB.$251.met1 VDD.$254.li1 0.00639308f
Cext_3445 NB.$251.met1 VDD.$426.met1 0.00183333f
Cext_3446 NB.$251.met1 VDD.$450.met1 0.00225301f
Cext_3447 NB.$251.met1 VDD.$487.met2 0.0195292f
Cext_3448 NB.$251.met1 VDD.$734.nwell 0.00158074f
Cext_3449 NB.$251.met1 sky130_gnd 0.00649879f
Cext_3450 NB.$252.met1 PB.P1.poly 0.0153921f
Cext_3451 NB.$252.met1 VDD.$255.li1 0.00639308f
Cext_3452 NB.$252.met1 VDD.$427.met1 0.00183333f
Cext_3453 NB.$252.met1 VDD.$451.met1 0.00225301f
Cext_3454 NB.$252.met1 VDD.$487.met2 0.0146735f
Cext_3455 NB.$252.met1 VDD.$735.nwell 0.00158074f
Cext_3456 NB.$252.met1 sky130_gnd 0.00649879f
Cext_3457 NB.$253.met1 PB.P1.poly 0.0153921f
Cext_3458 NB.$253.met1 VDD.$256.li1 0.00639308f
Cext_3459 NB.$253.met1 VDD.$428.met1 0.00183333f
Cext_3460 NB.$253.met1 VDD.$452.met1 0.00225301f
Cext_3461 NB.$253.met1 VDD.$487.met2 0.014273f
Cext_3462 NB.$253.met1 VDD.$736.nwell 0.00198128f
Cext_3463 NB.$253.met1 sky130_gnd 0.00649879f
Cext_3464 NB.$254.met1 PB.P1.poly 0.0153921f
Cext_3465 NB.$254.met1 VDD.$257.li1 0.00639308f
Cext_3466 NB.$254.met1 VDD.$429.met1 0.00183333f
Cext_3467 NB.$254.met1 VDD.$453.met1 0.00225301f
Cext_3468 NB.$254.met1 VDD.$487.met2 0.0141359f
Cext_3469 NB.$254.met1 VDD.$737.nwell 0.00211832f
Cext_3470 NB.$254.met1 sky130_gnd 0.00649879f
Cext_3471 NB.$255.met1 PB.P1.poly 0.0151243f
Cext_3472 NB.$255.met1 VDD.$258.li1 0.00400191f
Cext_3473 NB.$255.met1 VDD.$270.li1 0.00347796f
Cext_3474 NB.$255.met1 VDD.$430.met1 0.00183333f
Cext_3475 NB.$255.met1 VDD.$442.met1 0.00424759f
Cext_3476 NB.$255.met1 VDD.$454.met1 0.0013253f
Cext_3477 NB.$255.met1 VDD.$487.met2 0.0145957f
Cext_3478 NB.$255.met1 VDD.$738.nwell 0.00111711f
Cext_3479 NB.$255.met1 sky130_gnd 0.00361044f
Cext_3480 NB.$256.met1 PB.P1.poly 0.0149893f
Cext_3481 NB.$256.met1 VDD.$259.li1 0.00387562f
Cext_3482 NB.$256.met1 VDD.$270.li1 0.0034867f
Cext_3483 NB.$256.met1 VDD.$431.met1 0.00183333f
Cext_3484 NB.$256.met1 VDD.$442.met1 0.00409302f
Cext_3485 NB.$256.met1 VDD.$487.met2 0.0145593f
Cext_3486 NB.$256.met1 VDD.$739.nwell 0.00134877f
Cext_3487 NB.$256.met1 sky130_gnd 0.00361044f
Cext_3488 NB.$257.met1 PB.P1.poly 0.0150526f
Cext_3489 NB.$257.met1 VDD.$260.li1 0.00603704f
Cext_3490 NB.$257.met1 VDD.$432.met1 0.00183333f
Cext_3491 NB.$257.met1 VDD.$487.met2 0.00541396f
Cext_3492 NB.$257.met1 VDD.$504.met3 0.0134458f
Cext_3493 NB.$257.met1 VDD.$740.nwell 0.00174205f
Cext_3494 NB.$257.met1 VDD.$750.nwell 0.00154707f
Cext_3495 NB.$257.met1 sky130_gnd 0.00649879f
Cext_3496 NB.$258.met1 PB.P1.poly 0.0153921f
Cext_3497 NB.$258.met1 VDD.$261.li1 0.00642435f
Cext_3498 NB.$258.met1 VDD.$433.met1 0.00183333f
Cext_3499 NB.$258.met1 VDD.$741.nwell 0.00158074f
Cext_3500 NB.$258.met1 sky130_gnd 0.0106614f
Cext_3501 NB.$259.met1 PB.P1.poly 0.0153921f
Cext_3502 NB.$259.met1 VDD.$262.li1 0.00642435f
Cext_3503 NB.$259.met1 VDD.$434.met1 0.00183333f
Cext_3504 NB.$259.met1 VDD.$742.nwell 0.00158074f
Cext_3505 NB.$259.met1 sky130_gnd 0.0106614f
Cext_3506 NB.$26.li1 sky130_gnd 0.0140353f
Cext_3507 NB.$260.met1 PB.P1.poly 0.0153486f
Cext_3508 NB.$260.met1 VDD.$263.li1 0.00642435f
Cext_3509 NB.$260.met1 VDD.$435.met1 0.00183333f
Cext_3510 NB.$260.met1 VDD.$743.nwell 0.00158074f
Cext_3511 NB.$260.met1 sky130_gnd 0.0106614f
Cext_3512 NB.$261.met1 PB.P1.poly 0.0151721f
Cext_3513 NB.$261.met1 VDD.$264.li1 0.00642435f
Cext_3514 NB.$261.met1 VDD.$436.met1 0.00183333f
Cext_3515 NB.$261.met1 VDD.$744.nwell 0.00158074f
Cext_3516 NB.$261.met1 sky130_gnd 0.0106614f
Cext_3517 NB.$262.met1 PB.$11535.poly 0.0144602f
Cext_3518 NB.$262.met1 VDD.$265.li1 0.00642435f
Cext_3519 NB.$262.met1 VDD.$437.met1 0.00183333f
Cext_3520 NB.$262.met1 VDD.$745.nwell 0.00158074f
Cext_3521 NB.$262.met1 sky130_gnd 0.0106614f
Cext_3522 NB.$263.met1 PB.$11535.poly 0.0153921f
Cext_3523 NB.$263.met1 VDD.$266.li1 0.00642435f
Cext_3524 NB.$263.met1 VDD.$438.met1 0.00183333f
Cext_3525 NB.$263.met1 VDD.$746.nwell 0.00158074f
Cext_3526 NB.$263.met1 sky130_gnd 0.0106614f
Cext_3527 NB.$264.met1 PB.$11535.poly 0.0153921f
Cext_3528 NB.$264.met1 VDD.$267.li1 0.00642435f
Cext_3529 NB.$264.met1 VDD.$439.met1 0.00183333f
Cext_3530 NB.$264.met1 VDD.$747.nwell 0.00158074f
Cext_3531 NB.$264.met1 sky130_gnd 0.0106614f
Cext_3532 NB.$265.met1 PB.$11535.poly 0.0153921f
Cext_3533 NB.$265.met1 VDD.$268.li1 0.00642435f
Cext_3534 NB.$265.met1 VDD.$440.met1 0.00183333f
Cext_3535 NB.$265.met1 VDD.$748.nwell 0.00158074f
Cext_3536 NB.$265.met1 sky130_gnd 0.0106614f
Cext_3537 NB.$266.met1 PB.$11535.poly 0.0138956f
Cext_3538 NB.$266.met1 VDD.$269.li1 0.00579976f
Cext_3539 NB.$266.met1 VDD.$441.met1 0.00165509f
Cext_3540 NB.$266.met1 VDD.$749.nwell 0.00387971f
Cext_3541 NB.$266.met1 sky130_gnd 0.0162332f
Cext_3542 NB.$267.met1 PB.$5938.met3 0.00536509f
Cext_3543 NB.$267.met1 VDD.$248.li1 0.00878726f
Cext_3544 NB.$267.met1 VDD.$249.li1 0.00112082f
Cext_3545 NB.$267.met1 VDD.$259.li1 0.00406404f
Cext_3546 NB.$267.met1 VDD.$444.met1 0.00182759f
Cext_3547 NB.$267.met1 VDD.$728.nwell 0.00293286f
Cext_3548 NB.$267.met1 sky130_gnd 0.00965654f
Cext_3549 NB.$268.met2 VSS.$380.met2 0.0144086f
Cext_3550 NB.$268.met2 sky130_gnd 0.0128265f
Cext_3551 NB.$269.met2 PB.$5920.met2 0.00264175f
Cext_3552 NB.$269.met2 VSS.$378.met2 0.00562076f
Cext_3553 NB.$269.met2 VSS.$380.met2 0.00315733f
Cext_3554 NB.$269.met2 sky130_gnd 0.0131364f
Cext_3555 NB.$270.met2 VREF 0.00263011f
Cext_3556 NB.$270.met2 VSS.$422.met3 0.0351384f
Cext_3557 NB.$270.met2 sky130_gnd 0.0209555f
Cext_3558 NB.$271.met2 VREF.$104.met2 0.0013587f
Cext_3559 NB.$271.met2 VSS.$274.met1 0.00425136f
Cext_3560 NB.$271.met2 VSS.$380.met2 0.00438397f
Cext_3561 NB.$271.met2 VSS.$393.met2 0.0119048f
Cext_3562 NB.$271.met2 VSS.$422.met3 0.0514197f
Cext_3563 NB.$271.met2 VSS.$65.li1 0.00108228f
Cext_3564 NB.$271.met2 sky130_gnd 0.0204659f
Cext_3565 NB.$272.met2 PB.$5942.met3 0.00169723f
Cext_3566 NB.$272.met2 VREF.$100.met2 0.00782839f
Cext_3567 NB.$272.met2 VREF.$107.met3 0.0188852f
Cext_3568 NB.$272.met2 VREF.$109.met3 0.0229693f
Cext_3569 NB.$272.met2 VSS 0.00644796f
Cext_3570 NB.$272.met2 VSS.$113.li1 0.00173472f
Cext_3571 NB.$272.met2 VSS.$275.met1 0.00611594f
Cext_3572 NB.$272.met2 VSS.$389.met2 0.00420779f
Cext_3573 NB.$272.met2 VSS.$390.met2 0.00658307f
Cext_3574 NB.$272.met2 VSS.$393.met2 0.0139086f
Cext_3575 NB.$272.met2 VSS.$422.met3 0.0397988f
Cext_3576 NB.$272.met2 VSS.$424.met3 0.0502835f
Cext_3577 NB.$272.met2 VSS.$67.li1 0.00479259f
Cext_3578 NB.$273.met2 VREF.$100.met2 0.0208508f
Cext_3579 NB.$273.met2 VREF.$103.met2 0.0042136f
Cext_3580 NB.$273.met2 VREF.$109.met3 0.0690602f
Cext_3581 NB.$273.met2 VSS 0.0141653f
Cext_3582 NB.$273.met2 VSS.$109.li1 0.034467f
Cext_3583 NB.$273.met2 VSS.$396.met2 0.0566866f
Cext_3584 NB.$273.met2 VSS.$424.met3 0.0266725f
Cext_3585 NB.$273.met2 sky130_gnd 0.240228f
Cext_3586 NB.$274.met2 PB.$11534.poly 0.058733f
Cext_3587 NB.$274.met2 PB.$5720.li1 0.00423974f
Cext_3588 NB.$274.met2 PB.$5724.li1 0.00786517f
Cext_3589 NB.$274.met2 PB.$5728.li1 0.00140257f
Cext_3590 NB.$274.met2 PB.$5732.li1 0.00140257f
Cext_3591 NB.$274.met2 PB.$5736.li1 0.00126621f
Cext_3592 NB.$274.met2 PB.$5886.met1 0.014292f
Cext_3593 NB.$274.met2 PB.$5892.met1 0.0165349f
Cext_3594 NB.$274.met2 PB.$5894.met1 0.031395f
Cext_3595 NB.$274.met2 PB.$5896.met1 0.00794215f
Cext_3596 NB.$274.met2 PB.$5898.met1 0.0206581f
Cext_3597 NB.$274.met2 PB.$5900.met1 0.00716999f
Cext_3598 NB.$274.met2 PB.$5924.met2 0.00566086f
Cext_3599 NB.$274.met2 PB.$5938.met3 0.125802f
Cext_3600 NB.$274.met2 PB.P1.poly 0.0676448f
Cext_3601 NB.$274.met2 VDD.$259.li1 0.00370264f
Cext_3602 NB.$274.met2 VDD.$503.met3 0.0118263f
Cext_3603 NB.$274.met2 VDD.$504.met3 0.00638208f
Cext_3604 NB.$274.met2 VDD.$706.nwell 0.00271672f
Cext_3605 NB.$274.met2 VDD.$728.nwell 0.0207315f
Cext_3606 NB.$274.met2 VDD.P1.nwell 0.00148667f
Cext_3607 NB.$274.met2 VREF.$100.met2 0.00813279f
Cext_3608 NB.$274.met2 VREF.$101.met2 0.035116f
Cext_3609 NB.$274.met2 sky130_gnd 0.765431f
Cext_3610 NB.$275.met3 PB.$5936.met3 0.0876203f
Cext_3611 NB.$275.met3 TAIL 0.0025683f
Cext_3612 NB.$275.met3 TAIL.$311.met1 0.00238555f
Cext_3613 NB.$275.met3 TAIL.$338.met2 0.00164809f
Cext_3614 NB.$275.met3 TAIL.$341.met3 0.143282f
Cext_3615 NB.$275.met3 VSS.$380.met2 0.0819718f
Cext_3616 NB.$275.met3 sky130_gnd 0.0679205f
Cext_3617 NB.$276.met3 PB.$5936.met3 0.0713224f
Cext_3618 NB.$276.met3 VSS.$274.met1 0.00259663f
Cext_3619 NB.$276.met3 VSS.$380.met2 0.0174019f
Cext_3620 NB.$276.met3 VSS.$392.met2 0.00553628f
Cext_3621 NB.$276.met3 VSS.$393.met2 0.00153187f
Cext_3622 NB.$276.met3 VSS.$422.met3 0.065184f
Cext_3623 NB.$276.met3 VSS.$67.li1 0.00229296f
Cext_3624 NB.$276.met3 sky130_gnd 0.109796f
Cext_3625 NB.$28.li1 VSS.$380.met2 0.00183394f
Cext_3626 NB.$28.li1 sky130_gnd 0.0140353f
Cext_3627 NB.$299.poly PB.$5920.met2 0.00443036f
Cext_3628 NB.$299.poly PB.$5936.met3 0.00617626f
Cext_3629 NB.$299.poly TAIL 0.00884167f
Cext_3630 NB.$299.poly TAIL.$176.li1 0.0172849f
Cext_3631 NB.$299.poly TAIL.$178.li1 0.0181392f
Cext_3632 NB.$299.poly TAIL.$180.li1 0.0180653f
Cext_3633 NB.$299.poly TAIL.$182.li1 0.0181392f
Cext_3634 NB.$299.poly TAIL.$184.li1 0.0171208f
Cext_3635 NB.$299.poly TAIL.$186.li1 0.00177361f
Cext_3636 NB.$299.poly TAIL.$310.met1 0.0214281f
Cext_3637 NB.$299.poly TAIL.$311.met1 0.0125855f
Cext_3638 NB.$299.poly TAIL.$313.met1 0.0144527f
Cext_3639 NB.$299.poly TAIL.$314.met1 0.0150995f
Cext_3640 NB.$299.poly TAIL.$315.met1 0.0141676f
Cext_3641 NB.$299.poly TAIL.$341.met3 0.0587529f
Cext_3642 NB.$299.poly VSS.$14.li1 0.0170878f
Cext_3643 NB.$299.poly VSS.$16.li1 0.0180407f
Cext_3644 NB.$299.poly VSS.$18.li1 0.0180653f
Cext_3645 NB.$299.poly VSS.$20.li1 0.0181392f
Cext_3646 NB.$299.poly VSS.$22.li1 0.017122f
Cext_3647 NB.$299.poly VSS.$236.met1 0.012638f
Cext_3648 NB.$299.poly VSS.$238.met1 0.0145038f
Cext_3649 NB.$299.poly VSS.$239.met1 0.0150995f
Cext_3650 NB.$299.poly VSS.$24.li1 0.0018417f
Cext_3651 NB.$299.poly VSS.$240.met1 0.0141676f
Cext_3652 NB.$299.poly VSS.$258.met1 0.021132f
Cext_3653 NB.$299.poly VSS.$378.met2 0.0212791f
Cext_3654 NB.$299.poly VSS.$379.met2 0.0332827f
Cext_3655 NB.$299.poly VSS.$380.met2 0.160089f
Cext_3656 NB.$299.poly VSS.$389.met2 0.00315277f
Cext_3657 NB.$299.poly VSS.$392.met2 0.00248652f
Cext_3658 NB.$299.poly VSS.$62.li1 0.00229044f
Cext_3659 NB.$299.poly sky130_gnd 0.501448f
Cext_3660 NB.$30.li1 sky130_gnd 0.0140353f
Cext_3661 NB.$300.poly TAIL.$208.li1 0.00177361f
Cext_3662 NB.$300.poly TAIL.$210.li1 0.0171696f
Cext_3663 NB.$300.poly TAIL.$212.li1 0.0188062f
Cext_3664 NB.$300.poly TAIL.$214.li1 0.0181925f
Cext_3665 NB.$300.poly TAIL.$216.li1 0.0181925f
Cext_3666 NB.$300.poly TAIL.$218.li1 0.0173329f
Cext_3667 NB.$300.poly TAIL.$328.met1 0.0142234f
Cext_3668 NB.$300.poly TAIL.$329.met1 0.0151553f
Cext_3669 NB.$300.poly TAIL.$330.met1 0.0151553f
Cext_3670 NB.$300.poly TAIL.$331.met1 0.0151553f
Cext_3671 NB.$300.poly TAIL.$332.met1 0.0136818f
Cext_3672 NB.$300.poly VREF.$100.met2 0.0584122f
Cext_3673 NB.$300.poly VSS.$103.li1 0.0010312f
Cext_3674 NB.$300.poly VSS.$105.li1 0.0010312f
Cext_3675 NB.$300.poly VSS.$13.li1 0.00324397f
Cext_3676 NB.$300.poly VSS.$234.met1 0.00238974f
Cext_3677 NB.$300.poly VSS.$253.met1 0.0141982f
Cext_3678 NB.$300.poly VSS.$254.met1 0.0151301f
Cext_3679 NB.$300.poly VSS.$255.met1 0.0151301f
Cext_3680 NB.$300.poly VSS.$256.met1 0.0150995f
Cext_3681 NB.$300.poly VSS.$257.met1 0.0135583f
Cext_3682 NB.$300.poly VSS.$376.met2 0.00431733f
Cext_3683 NB.$300.poly VSS.$377.met2 0.0319352f
Cext_3684 NB.$300.poly VSS.$379.met2 0.00627383f
Cext_3685 NB.$300.poly VSS.$417.met3 0.0102765f
Cext_3686 NB.$300.poly VSS.$46.li1 0.00177361f
Cext_3687 NB.$300.poly VSS.$48.li1 0.0171164f
Cext_3688 NB.$300.poly VSS.$50.li1 0.0181392f
Cext_3689 NB.$300.poly VSS.$52.li1 0.0181392f
Cext_3690 NB.$300.poly VSS.$54.li1 0.0181392f
Cext_3691 NB.$300.poly VSS.$56.li1 0.017211f
Cext_3692 NB.$300.poly VSS.$62.li1 0.00229044f
Cext_3693 NB.$300.poly sky130_gnd 0.500656f
Cext_3694 NB.$32.li1 VSS.$380.met2 0.00237149f
Cext_3695 NB.$32.li1 sky130_gnd 0.0140353f
Cext_3696 NB.$321.poly PB.$5936.met3 0.00203167f
Cext_3697 NB.$321.poly PB.$5942.met3 0.0213824f
Cext_3698 NB.$321.poly VREF 0.00191117f
Cext_3699 NB.$321.poly VREF.$104.met2 0.00323794f
Cext_3700 NB.$321.poly VREF.$111.poly 0.00177134f
Cext_3701 NB.$321.poly VREF.$112.poly 0.0027606f
Cext_3702 NB.$321.poly VREF.P0.poly 0.00175408f
Cext_3703 NB.$321.poly VSS 0.00168142f
Cext_3704 NB.$321.poly VSS.$109.li1 0.00243112f
Cext_3705 NB.$321.poly VSS.$113.li1 0.00144294f
Cext_3706 NB.$321.poly VSS.$274.met1 0.0135681f
Cext_3707 NB.$321.poly VSS.$275.met1 0.0149246f
Cext_3708 NB.$321.poly VSS.$276.met1 0.015179f
Cext_3709 NB.$321.poly VSS.$277.met1 0.0150995f
Cext_3710 NB.$321.poly VSS.$278.met1 0.0141676f
Cext_3711 NB.$321.poly VSS.$393.met2 0.0370982f
Cext_3712 NB.$321.poly VSS.$422.met3 0.0509685f
Cext_3713 NB.$321.poly VSS.$424.met3 0.0110113f
Cext_3714 NB.$321.poly VSS.$65.li1 0.0172849f
Cext_3715 NB.$321.poly VSS.$67.li1 0.0181392f
Cext_3716 NB.$321.poly VSS.$69.li1 0.0180653f
Cext_3717 NB.$321.poly VSS.$71.li1 0.0181392f
Cext_3718 NB.$321.poly VSS.$73.li1 0.0171164f
Cext_3719 NB.$321.poly VSS.$75.li1 0.00177361f
Cext_3720 NB.$321.poly sky130_gnd 0.501448f
Cext_3721 NB.$322.poly VREF.$100.met2 0.0294466f
Cext_3722 NB.$322.poly VREF.$107.met3 0.0820304f
Cext_3723 NB.$322.poly VREF.$109.met3 0.0284134f
Cext_3724 NB.$322.poly VSS.$100.li1 0.0171528f
Cext_3725 NB.$322.poly VSS.$101.li1 0.0182339f
Cext_3726 NB.$322.poly VSS.$103.li1 0.0182438f
Cext_3727 NB.$322.poly VSS.$105.li1 0.019017f
Cext_3728 NB.$322.poly VSS.$107.li1 0.0173793f
Cext_3729 NB.$322.poly VSS.$109.li1 0.00596578f
Cext_3730 NB.$322.poly VSS.$291.met1 0.0142294f
Cext_3731 NB.$322.poly VSS.$292.met1 0.0151613f
Cext_3732 NB.$322.poly VSS.$293.met1 0.0151613f
Cext_3733 NB.$322.poly VSS.$294.met1 0.0151613f
Cext_3734 NB.$322.poly VSS.$295.met1 0.0136591f
Cext_3735 NB.$322.poly VSS.$97.li1 0.00177361f
Cext_3736 NB.$322.poly sky130_gnd 0.503057f
Cext_3737 NB.$34.li1 sky130_gnd 0.0140353f
Cext_3738 NB.$36.li1 sky130_gnd 0.0140353f
Cext_3739 NB.$38.li1 sky130_gnd 0.0140353f
Cext_3740 NB.$4.li1 VSS.$378.met2 0.0011473f
Cext_3741 NB.$4.li1 sky130_gnd 0.0140353f
Cext_3742 NB.$40.li1 sky130_gnd 0.0191686f
Cext_3743 NB.$42.li1 sky130_gnd 0.0191686f
Cext_3744 NB.$44.li1 sky130_gnd 0.0191686f
Cext_3745 NB.$46.li1 sky130_gnd 0.0191686f
Cext_3746 NB.$48.li1 sky130_gnd 0.0140353f
Cext_3747 NB.$50.li1 sky130_gnd 0.0140353f
Cext_3748 NB.$52.li1 sky130_gnd 0.0140353f
Cext_3749 NB.$54.li1 sky130_gnd 0.0140353f
Cext_3750 NB.$56.li1 sky130_gnd 0.0140353f
Cext_3751 NB.$58.li1 sky130_gnd 0.0140353f
Cext_3752 NB.$6.li1 sky130_gnd 0.0140353f
Cext_3753 NB.$60.li1 sky130_gnd 0.0140353f
Cext_3754 NB.$62.li1 sky130_gnd 0.0140353f
Cext_3755 NB.$64.li1 sky130_gnd 0.0140353f
Cext_3756 NB.$66.li1 sky130_gnd 0.0140353f
Cext_3757 NB.$68.li1 sky130_gnd 0.0140353f
Cext_3758 NB.$70.li1 sky130_gnd 0.0140353f
Cext_3759 NB.$72.li1 sky130_gnd 0.0140353f
Cext_3760 NB.$74.li1 sky130_gnd 0.0140353f
Cext_3761 NB.$76.li1 sky130_gnd 0.0140353f
Cext_3762 NB.$78.li1 sky130_gnd 0.0140353f
Cext_3763 NB.$8.li1 sky130_gnd 0.0140353f
Cext_3764 NB.$80.li1 sky130_gnd 0.0140353f
Cext_3765 NB.$82.li1 sky130_gnd 0.0140353f
Cext_3766 NB.$84.li1 sky130_gnd 0.0191556f
Cext_3767 NB.$86.li1 sky130_gnd 0.020242f
Cext_3768 NB.$88.li1 VSS 0.00119339f
Cext_3769 NB.$88.li1 VSS.$111.li1 0.01275f
Cext_3770 NB.$88.li1 VSS.$65.li1 0.00103015f
Cext_3771 NB.$88.li1 sky130_gnd 0.00671871f
Cext_3772 NB.$90.li1 VSS 0.00151469f
Cext_3773 NB.$90.li1 VSS.$111.li1 0.00369565f
Cext_3774 NB.$90.li1 VSS.$113.li1 0.0096087f
Cext_3775 NB.$90.li1 VSS.$67.li1 0.00107494f
Cext_3776 NB.$92.li1 VSS 0.00142289f
Cext_3777 NB.$92.li1 VSS.$113.li1 0.0133043f
Cext_3778 NB.$92.li1 VSS.$69.li1 0.00107494f
Cext_3779 NB.$94.li1 VSS 0.00165239f
Cext_3780 NB.$94.li1 VSS.$109.li1 0.00691863f
Cext_3781 NB.$94.li1 VSS.$113.li1 0.00638571f
Cext_3782 NB.$94.li1 VSS.$71.li1 0.00107494f
Cext_3783 NB.$96.li1 VSS.$109.li1 0.0149598f
Cext_3784 NB.$96.li1 VSS.$73.li1 0.00107494f
Cext_3785 NB.$98.li1 VSS.$109.li1 0.0149932f
Cext_3786 NB.$98.li1 VSS.$75.li1 0.00107494f
Cext_3787 NB.P0.nsdm VREF.$109.met3 0.00392734f
Cext_3788 NB.P0.nsdm VSS.$109.li1 0.0154062f
Cext_3789 NB.P0.nsdm VSS.$113.li1 0.00151099f
Cext_3790 NB.P0.nsdm VSS.$396.met2 0.00149006f
Cext_3791 NB.P0.poly TAIL.$184.li1 0.00102285f
Cext_3792 NB.P0.poly TAIL.$186.li1 0.0164188f
Cext_3793 NB.P0.poly TAIL.$188.li1 0.0178421f
Cext_3794 NB.P0.poly TAIL.$190.li1 0.0181925f
Cext_3795 NB.P0.poly TAIL.$192.li1 0.0181925f
Cext_3796 NB.P0.poly TAIL.$194.li1 0.018151f
Cext_3797 NB.P0.poly TAIL.$196.li1 0.0180653f
Cext_3798 NB.P0.poly TAIL.$198.li1 0.0180653f
Cext_3799 NB.P0.poly TAIL.$200.li1 0.0181392f
Cext_3800 NB.P0.poly TAIL.$202.li1 0.0200429f
Cext_3801 NB.P0.poly TAIL.$204.li1 0.0181925f
Cext_3802 NB.P0.poly TAIL.$206.li1 0.0178421f
Cext_3803 NB.P0.poly TAIL.$208.li1 0.0164188f
Cext_3804 NB.P0.poly TAIL.$210.li1 0.00102285f
Cext_3805 NB.P0.poly TAIL.$310.met1 0.00581038f
Cext_3806 NB.P0.poly TAIL.$316.met1 0.0149101f
Cext_3807 NB.P0.poly TAIL.$317.met1 0.0150866f
Cext_3808 NB.P0.poly TAIL.$318.met1 0.0151301f
Cext_3809 NB.P0.poly TAIL.$319.met1 0.0151301f
Cext_3810 NB.P0.poly TAIL.$320.met1 0.0151301f
Cext_3811 NB.P0.poly TAIL.$321.met1 0.0149834f
Cext_3812 NB.P0.poly TAIL.$322.met1 0.0149101f
Cext_3813 NB.P0.poly TAIL.$323.met1 0.0151301f
Cext_3814 NB.P0.poly TAIL.$324.met1 0.0151184f
Cext_3815 NB.P0.poly TAIL.$325.met1 0.0151553f
Cext_3816 NB.P0.poly TAIL.$326.met1 0.0151118f
Cext_3817 NB.P0.poly TAIL.$327.met1 0.0149353f
Cext_3818 NB.P0.poly VREF.$100.met2 0.0474983f
Cext_3819 NB.P0.poly VREF.$107.met3 0.0150378f
Cext_3820 NB.P0.poly VSS.$22.li1 0.00102285f
Cext_3821 NB.P0.poly VSS.$24.li1 0.0163656f
Cext_3822 NB.P0.poly VSS.$241.met1 0.0149101f
Cext_3823 NB.P0.poly VSS.$242.met1 0.0150866f
Cext_3824 NB.P0.poly VSS.$243.met1 0.0151301f
Cext_3825 NB.P0.poly VSS.$244.met1 0.0151301f
Cext_3826 NB.P0.poly VSS.$245.met1 0.0151301f
Cext_3827 NB.P0.poly VSS.$246.met1 0.0151301f
Cext_3828 NB.P0.poly VSS.$247.met1 0.0151301f
Cext_3829 NB.P0.poly VSS.$248.met1 0.0151301f
Cext_3830 NB.P0.poly VSS.$249.met1 0.0151301f
Cext_3831 NB.P0.poly VSS.$250.met1 0.0151301f
Cext_3832 NB.P0.poly VSS.$251.met1 0.0150866f
Cext_3833 NB.P0.poly VSS.$252.met1 0.0149101f
Cext_3834 NB.P0.poly VSS.$258.met1 0.00441741f
Cext_3835 NB.P0.poly VSS.$26.li1 0.0178435f
Cext_3836 NB.P0.poly VSS.$28.li1 0.0182073f
Cext_3837 NB.P0.poly VSS.$30.li1 0.0182073f
Cext_3838 NB.P0.poly VSS.$32.li1 0.0181543f
Cext_3839 NB.P0.poly VSS.$34.li1 0.0181846f
Cext_3840 NB.P0.poly VSS.$36.li1 0.0182073f
Cext_3841 NB.P0.poly VSS.$377.met2 0.0383358f
Cext_3842 NB.P0.poly VSS.$378.met2 0.0347858f
Cext_3843 NB.P0.poly VSS.$379.met2 0.0761335f
Cext_3844 NB.P0.poly VSS.$38.li1 0.0182073f
Cext_3845 NB.P0.poly VSS.$380.met2 0.116541f
Cext_3846 NB.P0.poly VSS.$389.met2 0.0646118f
Cext_3847 NB.P0.poly VSS.$390.met2 0.00655676f
Cext_3848 NB.P0.poly VSS.$40.li1 0.0182073f
Cext_3849 NB.P0.poly VSS.$42.li1 0.0182046f
Cext_3850 NB.P0.poly VSS.$44.li1 0.0177889f
Cext_3851 NB.P0.poly VSS.$46.li1 0.0163656f
Cext_3852 NB.P0.poly VSS.$48.li1 0.00102285f
Cext_3853 NB.P0.poly VSS.$62.li1 0.0107787f
Cext_3854 NB.P0.psdm VDD.$487.met2 0.00203017f
Cext_3855 NB.P0.psdm VDD.$504.met3 0.00473459f
Cext_3856 NB.P1.poly VREF.$100.met2 0.0245051f
Cext_3857 NB.P1.poly VREF.$103.met2 0.0010199f
Cext_3858 NB.P1.poly VREF.$107.met3 0.102038f
Cext_3859 NB.P1.poly VREF.$109.met3 0.0329186f
Cext_3860 NB.P1.poly VSS.$100.li1 0.00102285f
Cext_3861 NB.P1.poly VSS.$109.li1 0.0107787f
Cext_3862 NB.P1.poly VSS.$279.met1 0.0149101f
Cext_3863 NB.P1.poly VSS.$280.met1 0.0150866f
Cext_3864 NB.P1.poly VSS.$281.met1 0.0151301f
Cext_3865 NB.P1.poly VSS.$282.met1 0.0151301f
Cext_3866 NB.P1.poly VSS.$283.met1 0.0151301f
Cext_3867 NB.P1.poly VSS.$284.met1 0.0149834f
Cext_3868 NB.P1.poly VSS.$285.met1 0.0149101f
Cext_3869 NB.P1.poly VSS.$286.met1 0.0151301f
Cext_3870 NB.P1.poly VSS.$287.met1 0.015123f
Cext_3871 NB.P1.poly VSS.$288.met1 0.0151613f
Cext_3872 NB.P1.poly VSS.$289.met1 0.0151179f
Cext_3873 NB.P1.poly VSS.$290.met1 0.0149414f
Cext_3874 NB.P1.poly VSS.$389.met2 0.00509338f
Cext_3875 NB.P1.poly VSS.$390.met2 0.0305852f
Cext_3876 NB.P1.poly VSS.$393.met2 0.0374465f
Cext_3877 NB.P1.poly VSS.$396.met2 0.00636454f
Cext_3878 NB.P1.poly VSS.$73.li1 0.00102285f
Cext_3879 NB.P1.poly VSS.$75.li1 0.0163656f
Cext_3880 NB.P1.poly VSS.$77.li1 0.0177889f
Cext_3881 NB.P1.poly VSS.$79.li1 0.0181554f
Cext_3882 NB.P1.poly VSS.$81.li1 0.0181757f
Cext_3883 NB.P1.poly VSS.$83.li1 0.0181757f
Cext_3884 NB.P1.poly VSS.$85.li1 0.0180815f
Cext_3885 NB.P1.poly VSS.$87.li1 0.0180653f
Cext_3886 NB.P1.poly VSS.$89.li1 0.0181392f
Cext_3887 NB.P1.poly VSS.$91.li1 0.0181666f
Cext_3888 NB.P1.poly VSS.$93.li1 0.0181757f
Cext_3889 NB.P1.poly VSS.$95.li1 0.0178254f
Cext_3890 NB.P1.poly VSS.$97.li1 0.0164021f
Cext_3891 net1.$579.met1 net2.$43.met1 0.00119413f
Cext_3892 net1.$579.met1 net2.$44.met1 0.00951188f
Cext_3893 net1.$585.met1 net2 0.0028998f
Cext_3894 net1.$621.met3 net2.$88.met2 0.00373093f
Cext_3895 net1.$621.met3 net2.$91.met3 1.14289f
Cext_3896 net1.$622.met3 net2.$89.met2 0.0688674f
Cext_3897 net1.$622.met3 net2.$90.met2 0.0224088f
Cext_3898 net1.$622.met3 net2.$91.met3 0.0195278f
Cext_3899 net1.$622.met3 net2.$92.met3 1.16917f
Cext_3900 PB.$0.capm VDD.$508.met3 4.11018f
Cext_3901 PB.$0.capm VDD.P0.met3 37.3601f
Cext_3902 PB.$100.capm VDD.$508.met3 2.47246f
Cext_3903 PB.$100.capm VDD.P0.met3 21.6678f
Cext_3904 PB.$1000.capm VDD.$508.met3 3.10565f
Cext_3905 PB.$1000.capm VDD.P0.met3 21.0346f
Cext_3906 PB.$10000.met4 net2.$92.met3 0.0012773f
Cext_3907 PB.$10000.met4 VDD.$508.met3 0.00541329f
Cext_3908 PB.$10000.met4 VDD.$511.met3 0.00507695f
Cext_3909 PB.$10000.met4 sky130_gnd 0.0235369f
Cext_3910 PB.$10017.met4 net2.$92.met3 0.00114379f
Cext_3911 PB.$10017.met4 VDD.$508.met3 0.00537861f
Cext_3912 PB.$10017.met4 VDD.$511.met3 0.00507695f
Cext_3913 PB.$10017.met4 sky130_gnd 0.0239185f
Cext_3914 PB.$10091.met4 net2.$92.met3 0.00114379f
Cext_3915 PB.$10091.met4 VDD.$508.met3 0.00537861f
Cext_3916 PB.$10091.met4 VDD.$511.met3 0.00507695f
Cext_3917 PB.$10091.met4 sky130_gnd 0.0239185f
Cext_3918 PB.$10165.met4 net2.$92.met3 0.0012773f
Cext_3919 PB.$10165.met4 VDD.$508.met3 0.00541329f
Cext_3920 PB.$10165.met4 VDD.$511.met3 0.00507695f
Cext_3921 PB.$10165.met4 sky130_gnd 0.0235369f
Cext_3922 PB.$10239.met4 net2.$92.met3 0.00104366f
Cext_3923 PB.$10239.met4 VDD.$508.met3 0.00535259f
Cext_3924 PB.$10239.met4 VDD.$511.met3 0.00507695f
Cext_3925 PB.$10239.met4 sky130_gnd 0.0242046f
Cext_3926 PB.$10313.met4 net2.$92.met3 0.0012773f
Cext_3927 PB.$10313.met4 VDD.$508.met3 0.00541329f
Cext_3928 PB.$10313.met4 VDD.$511.met3 0.00507695f
Cext_3929 PB.$10313.met4 sky130_gnd 0.0235369f
Cext_3930 PB.$1036.capm VDD.$508.met3 3.15842f
Cext_3931 PB.$1036.capm VDD.P0.met3 20.9818f
Cext_3932 PB.$10387.met4 net2.$92.met3 0.00114379f
Cext_3933 PB.$10387.met4 VDD.$511.met3 0.00966242f
Cext_3934 PB.$10387.met4 sky130_gnd 0.0239185f
Cext_3935 PB.$10461.met4 net2.$92.met3 0.00114379f
Cext_3936 PB.$10461.met4 VDD.$511.met3 0.0104556f
Cext_3937 PB.$10461.met4 sky130_gnd 0.0239185f
Cext_3938 PB.$10535.met4 net2.$92.met3 0.00111408f
Cext_3939 PB.$10535.met4 VDD.$511.met3 0.0104472f
Cext_3940 PB.$10535.met4 sky130_gnd 0.022638f
Cext_3941 PB.$10609.met4 net2.$92.met3 0.00104366f
Cext_3942 PB.$10609.met4 VDD.$511.met3 0.0104295f
Cext_3943 PB.$10609.met4 sky130_gnd 0.020969f
Cext_3944 PB.$10683.met4 net2.$92.met3 0.00605831f
Cext_3945 PB.$10683.met4 VDD.$511.met3 0.0104471f
Cext_3946 PB.$10683.met4 sky130_gnd 0.0198616f
Cext_3947 PB.$10757.met4 net2.$92.met3 0.00109464f
Cext_3948 PB.$10757.met4 VDD.$511.met3 0.0104124f
Cext_3949 PB.$10757.met4 sky130_gnd 0.020188f
Cext_3950 PB.$10831.met4 net2.$92.met3 0.00114379f
Cext_3951 PB.$10831.met4 VDD.$511.met3 0.0104556f
Cext_3952 PB.$10831.met4 sky130_gnd 0.0207322f
Cext_3953 PB.$10905.met4 net2.$92.met3 0.0012773f
Cext_3954 PB.$10905.met4 VDD.$511.met3 0.0104558f
Cext_3955 PB.$10905.met4 sky130_gnd 0.0204163f
Cext_3956 PB.$10979.met4 VDD.$511.met3 0.0103606f
Cext_3957 PB.$10979.met4 sky130_gnd 0.0231428f
Cext_3958 PB.$11053.met4 net2.$92.met3 0.0012773f
Cext_3959 PB.$11053.met4 VDD.$511.met3 0.0104902f
Cext_3960 PB.$11053.met4 sky130_gnd 0.0234202f
Cext_3961 PB.$1110.capm VDD.$508.met3 3.21119f
Cext_3962 PB.$1110.capm VDD.P0.met3 20.9291f
Cext_3963 PB.$11127.met4 net2.$92.met3 0.00114379f
Cext_3964 PB.$11127.met4 VDD.$511.met3 0.0104556f
Cext_3965 PB.$11127.met4 sky130_gnd 0.0238137f
Cext_3966 PB.$11201.met4 net2.$92.met3 0.00114379f
Cext_3967 PB.$11201.met4 VDD.$511.met3 0.0104556f
Cext_3968 PB.$11201.met4 sky130_gnd 0.0238137f
Cext_3969 PB.$11275.met4 net2.$92.met3 0.0012773f
Cext_3970 PB.$11275.met4 VDD.$511.met3 0.0104902f
Cext_3971 PB.$11275.met4 sky130_gnd 0.0234202f
Cext_3972 PB.$11349.met4 net2.$92.met3 0.00105671f
Cext_3973 PB.$11349.met4 VDD 0.0209024f
Cext_3974 PB.$11349.met4 VDD.$511.met3 1.13305f
Cext_3975 PB.$11349.met4 VDD.$587.met4 0.00500519f
Cext_3976 PB.$11349.met4 VDD.$588.met4 0.0105288f
Cext_3977 PB.$11349.met4 VDD.$589.met4 0.0105288f
Cext_3978 PB.$11349.met4 VDD.$590.met4 0.00976623f
Cext_3979 PB.$11349.met4 VDD.$591.met4 0.0112913f
Cext_3980 PB.$11349.met4 VDD.$592.met4 0.00976623f
Cext_3981 PB.$11349.met4 VDD.$593.met4 0.0105288f
Cext_3982 PB.$11349.met4 VDD.$594.met4 0.0105288f
Cext_3983 PB.$11349.met4 VDD.$595.met4 0.00976623f
Cext_3984 PB.$11349.met4 VDD.$596.met4 0.0112913f
Cext_3985 PB.$11349.met4 VDD.$597.met4 0.00976623f
Cext_3986 PB.$11349.met4 VDD.$598.met4 0.0105288f
Cext_3987 PB.$11349.met4 VDD.$599.met4 0.0105288f
Cext_3988 PB.$11349.met4 VDD.$600.met4 0.00976623f
Cext_3989 PB.$11349.met4 VDD.$601.met4 0.0112913f
Cext_3990 PB.$11349.met4 VDD.$602.met4 0.00976623f
Cext_3991 PB.$11349.met4 VDD.$603.met4 0.0105288f
Cext_3992 PB.$11349.met4 VDD.$604.met4 0.0105288f
Cext_3993 PB.$11349.met4 VDD.$605.met4 0.00976623f
Cext_3994 PB.$11349.met4 VDD.$606.met4 0.0112913f
Cext_3995 PB.$11349.met4 VDD.$607.met4 0.00976623f
Cext_3996 PB.$11349.met4 VDD.$608.met4 0.0105288f
Cext_3997 PB.$11349.met4 VDD.$609.met4 0.0105288f
Cext_3998 PB.$11349.met4 VDD.$610.met4 0.00976623f
Cext_3999 PB.$11349.met4 VDD.$611.met4 0.0112913f
Cext_4000 PB.$11349.met4 VDD.$612.met4 0.00976623f
Cext_4001 PB.$11349.met4 VDD.$613.met4 0.0105288f
Cext_4002 PB.$11349.met4 VDD.$614.met4 0.0105288f
Cext_4003 PB.$11349.met4 VDD.$615.met4 0.00976623f
Cext_4004 PB.$11349.met4 VDD.$616.met4 0.0112913f
Cext_4005 PB.$11349.met4 VDD.$617.met4 0.00976623f
Cext_4006 PB.$11349.met4 VDD.$618.met4 0.0105288f
Cext_4007 PB.$11349.met4 VDD.$619.met4 0.0105288f
Cext_4008 PB.$11349.met4 VDD.$620.met4 0.00976623f
Cext_4009 PB.$11349.met4 VDD.$621.met4 0.0112913f
Cext_4010 PB.$11349.met4 VDD.$622.met4 0.00976623f
Cext_4011 PB.$11349.met4 VDD.$623.met4 0.0105288f
Cext_4012 PB.$11349.met4 VDD.$624.met4 0.0105288f
Cext_4013 PB.$11349.met4 VDD.$625.met4 0.00976623f
Cext_4014 PB.$11349.met4 VDD.$626.met4 0.0112913f
Cext_4015 PB.$11349.met4 VDD.$627.met4 0.00976623f
Cext_4016 PB.$11349.met4 VDD.$628.met4 0.0105288f
Cext_4017 PB.$11349.met4 VDD.$629.met4 0.0105288f
Cext_4018 PB.$11349.met4 VDD.$630.met4 0.00976623f
Cext_4019 PB.$11349.met4 VDD.$631.met4 0.0112913f
Cext_4020 PB.$11349.met4 VDD.$632.met4 0.00976623f
Cext_4021 PB.$11349.met4 VDD.$633.met4 0.0105288f
Cext_4022 PB.$11349.met4 VDD.$634.met4 0.0105288f
Cext_4023 PB.$11349.met4 VDD.$635.met4 0.00976623f
Cext_4024 PB.$11349.met4 VDD.$636.met4 0.0112913f
Cext_4025 PB.$11349.met4 VDD.$637.met4 0.00976623f
Cext_4026 PB.$11349.met4 VDD.$638.met4 0.0105288f
Cext_4027 PB.$11349.met4 VDD.$639.met4 0.0105288f
Cext_4028 PB.$11349.met4 VDD.$640.met4 0.00976623f
Cext_4029 PB.$11349.met4 VDD.$641.met4 0.0112913f
Cext_4030 PB.$11349.met4 VDD.$642.met4 0.00976623f
Cext_4031 PB.$11349.met4 VDD.$643.met4 0.0105288f
Cext_4032 PB.$11349.met4 VDD.$644.met4 0.0105288f
Cext_4033 PB.$11349.met4 VDD.$645.met4 0.00976623f
Cext_4034 PB.$11349.met4 VDD.$646.met4 0.0112913f
Cext_4035 PB.$11349.met4 VDD.$647.met4 0.00976623f
Cext_4036 PB.$11349.met4 VDD.$648.met4 0.0105288f
Cext_4037 PB.$11349.met4 VDD.$649.met4 0.0105288f
Cext_4038 PB.$11349.met4 VDD.$650.met4 0.00976623f
Cext_4039 PB.$11349.met4 VDD.$651.met4 0.0112913f
Cext_4040 PB.$11349.met4 VDD.$652.met4 0.00976623f
Cext_4041 PB.$11349.met4 VDD.$653.met4 0.0105288f
Cext_4042 PB.$11349.met4 VDD.$654.met4 0.0105288f
Cext_4043 PB.$11349.met4 VDD.$655.met4 0.00976623f
Cext_4044 PB.$11349.met4 VDD.$656.met4 0.0112913f
Cext_4045 PB.$11349.met4 VDD.$657.met4 0.00976623f
Cext_4046 PB.$11349.met4 VDD.$658.met4 0.00366234f
Cext_4047 PB.$11349.met4 VDD.$660.met4 0.00921787f
Cext_4048 PB.$11349.met4 VDD.$661.met4 0.00596594f
Cext_4049 PB.$11349.met4 sky130_gnd 0.0244102f
Cext_4050 PB.$11468.poly VDD.$0.li1 0.0172849f
Cext_4051 PB.$11468.poly VDD.$10.li1 0.00177361f
Cext_4052 PB.$11468.poly VDD.$2.li1 0.0181392f
Cext_4053 PB.$11468.poly VDD.$345.met1 0.0135496f
Cext_4054 PB.$11468.poly VDD.$346.met1 0.0150799f
Cext_4055 PB.$11468.poly VDD.$347.met1 0.0150995f
Cext_4056 PB.$11468.poly VDD.$348.met1 0.0151301f
Cext_4057 PB.$11468.poly VDD.$349.met1 0.0141676f
Cext_4058 PB.$11468.poly VDD.$4.li1 0.0181392f
Cext_4059 PB.$11468.poly VDD.$45.li1 0.00103443f
Cext_4060 PB.$11468.poly VDD.$46.li1 0.00103443f
Cext_4061 PB.$11468.poly VDD.$47.li1 0.00103443f
Cext_4062 PB.$11468.poly VDD.$476.met2 0.0217221f
Cext_4063 PB.$11468.poly VDD.$477.met2 0.0108219f
Cext_4064 PB.$11468.poly VDD.$479.met2 0.00948626f
Cext_4065 PB.$11468.poly VDD.$48.li1 0.00103443f
Cext_4066 PB.$11468.poly VDD.$480.met2 0.00263723f
Cext_4067 PB.$11468.poly VDD.$49.li1 0.00103443f
Cext_4068 PB.$11468.poly VDD.$500.met3 0.0509482f
Cext_4069 PB.$11468.poly VDD.$501.met3 0.0110266f
Cext_4070 PB.$11468.poly VDD.$6.li1 0.0181392f
Cext_4071 PB.$11468.poly VDD.$662.nwell 0.316338f
Cext_4072 PB.$11468.poly VDD.$8.li1 0.0171164f
Cext_4073 PB.$11468.poly VDD.P3.nwell 0.00782929f
Cext_4074 PB.$11468.poly sky130_gnd 0.174601f
Cext_4075 PB.$11469.poly VDD.$32.li1 0.00177361f
Cext_4076 PB.$11469.poly VDD.$34.li1 0.0171164f
Cext_4077 PB.$11469.poly VDD.$36.li1 0.0181392f
Cext_4078 PB.$11469.poly VDD.$362.met1 0.0141982f
Cext_4079 PB.$11469.poly VDD.$363.met1 0.0151301f
Cext_4080 PB.$11469.poly VDD.$364.met1 0.0151301f
Cext_4081 PB.$11469.poly VDD.$365.met1 0.0151301f
Cext_4082 PB.$11469.poly VDD.$366.met1 0.0136591f
Cext_4083 PB.$11469.poly VDD.$38.li1 0.0181392f
Cext_4084 PB.$11469.poly VDD.$40.li1 0.0181392f
Cext_4085 PB.$11469.poly VDD.$42.li1 0.0172849f
Cext_4086 PB.$11469.poly VDD.$60.li1 0.00103443f
Cext_4087 PB.$11469.poly VDD.$61.li1 0.00103443f
Cext_4088 PB.$11469.poly VDD.$62.li1 0.00103443f
Cext_4089 PB.$11469.poly VDD.$63.li1 0.00103443f
Cext_4090 PB.$11469.poly VDD.$64.li1 0.00103443f
Cext_4091 PB.$11469.poly VDD.$683.nwell 0.316525f
Cext_4092 PB.$11469.poly VDD.P3.nwell 0.00837997f
Cext_4093 PB.$11469.poly sky130_gnd 0.182254f
Cext_4094 PB.$11490.poly VDD.$113.li1 0.00103443f
Cext_4095 PB.$11490.poly VDD.$114.li1 0.00103443f
Cext_4096 PB.$11490.poly VDD.$115.li1 0.00103443f
Cext_4097 PB.$11490.poly VDD.$116.li1 0.00103443f
Cext_4098 PB.$11490.poly VDD.$117.li1 0.00103443f
Cext_4099 PB.$11490.poly VDD.$370.met1 0.0134734f
Cext_4100 PB.$11490.poly VDD.$371.met1 0.01504f
Cext_4101 PB.$11490.poly VDD.$372.met1 0.0150995f
Cext_4102 PB.$11490.poly VDD.$373.met1 0.0151301f
Cext_4103 PB.$11490.poly VDD.$374.met1 0.0141676f
Cext_4104 PB.$11490.poly VDD.$479.met2 0.0361978f
Cext_4105 PB.$11490.poly VDD.$480.met2 0.0238673f
Cext_4106 PB.$11490.poly VDD.$482.met2 0.00241755f
Cext_4107 PB.$11490.poly VDD.$483.met2 0.00801671f
Cext_4108 PB.$11490.poly VDD.$501.met3 0.0577913f
Cext_4109 PB.$11490.poly VDD.$502.met3 0.00480138f
Cext_4110 PB.$11490.poly VDD.$662.nwell 0.0671955f
Cext_4111 PB.$11490.poly VDD.$68.li1 0.017211f
Cext_4112 PB.$11490.poly VDD.$684.nwell 0.25903f
Cext_4113 PB.$11490.poly VDD.$70.li1 0.0181392f
Cext_4114 PB.$11490.poly VDD.$72.li1 0.0181392f
Cext_4115 PB.$11490.poly VDD.$74.li1 0.0181392f
Cext_4116 PB.$11490.poly VDD.$76.li1 0.0171164f
Cext_4117 PB.$11490.poly VDD.$78.li1 0.00177361f
Cext_4118 PB.$11490.poly sky130_gnd 0.17241f
Cext_4119 PB.$11491.poly VDD.$100.li1 0.00177361f
Cext_4120 PB.$11491.poly VDD.$102.li1 0.0171164f
Cext_4121 PB.$11491.poly VDD.$104.li1 0.0181392f
Cext_4122 PB.$11491.poly VDD.$106.li1 0.0181392f
Cext_4123 PB.$11491.poly VDD.$108.li1 0.0181392f
Cext_4124 PB.$11491.poly VDD.$110.li1 0.0172849f
Cext_4125 PB.$11491.poly VDD.$128.li1 0.00103443f
Cext_4126 PB.$11491.poly VDD.$129.li1 0.00103443f
Cext_4127 PB.$11491.poly VDD.$130.li1 0.00103443f
Cext_4128 PB.$11491.poly VDD.$131.li1 0.00103443f
Cext_4129 PB.$11491.poly VDD.$132.li1 0.00103443f
Cext_4130 PB.$11491.poly VDD.$387.met1 0.0141982f
Cext_4131 PB.$11491.poly VDD.$388.met1 0.0151301f
Cext_4132 PB.$11491.poly VDD.$389.met1 0.0151301f
Cext_4133 PB.$11491.poly VDD.$390.met1 0.0151301f
Cext_4134 PB.$11491.poly VDD.$391.met1 0.0136591f
Cext_4135 PB.$11491.poly VDD.$683.nwell 0.0669458f
Cext_4136 PB.$11491.poly VDD.$705.nwell 0.258972f
Cext_4137 PB.$11491.poly sky130_gnd 0.179927f
Cext_4138 PB.$11512.poly VDD.$136.li1 0.017211f
Cext_4139 PB.$11512.poly VDD.$138.li1 0.0181392f
Cext_4140 PB.$11512.poly VDD.$140.li1 0.0181392f
Cext_4141 PB.$11512.poly VDD.$142.li1 0.0181392f
Cext_4142 PB.$11512.poly VDD.$144.li1 0.0171164f
Cext_4143 PB.$11512.poly VDD.$146.li1 0.00177361f
Cext_4144 PB.$11512.poly VDD.$181.li1 0.00103443f
Cext_4145 PB.$11512.poly VDD.$182.li1 0.00103443f
Cext_4146 PB.$11512.poly VDD.$183.li1 0.00103443f
Cext_4147 PB.$11512.poly VDD.$184.li1 0.00103443f
Cext_4148 PB.$11512.poly VDD.$185.li1 0.00103443f
Cext_4149 PB.$11512.poly VDD.$394.met1 0.0016674f
Cext_4150 PB.$11512.poly VDD.$395.met1 0.0130626f
Cext_4151 PB.$11512.poly VDD.$396.met1 0.0150995f
Cext_4152 PB.$11512.poly VDD.$397.met1 0.0151301f
Cext_4153 PB.$11512.poly VDD.$398.met1 0.0141676f
Cext_4154 PB.$11512.poly VDD.$416.met1 0.0174914f
Cext_4155 PB.$11512.poly VDD.$482.met2 0.0290253f
Cext_4156 PB.$11512.poly VDD.$483.met2 0.0506269f
Cext_4157 PB.$11512.poly VDD.$485.met2 0.0105213f
Cext_4158 PB.$11512.poly VDD.$486.met2 0.00242509f
Cext_4159 PB.$11512.poly VDD.$502.met3 0.0810497f
Cext_4160 PB.$11512.poly VDD.$503.met3 0.00900768f
Cext_4161 PB.$11512.poly VDD.$684.nwell 0.0671955f
Cext_4162 PB.$11512.poly VDD.$706.nwell 0.257423f
Cext_4163 PB.$11512.poly VREF.$0.li1 0.017211f
Cext_4164 PB.$11512.poly VREF.$10.li1 0.00177361f
Cext_4165 PB.$11512.poly VREF.$101.met2 0.0307945f
Cext_4166 PB.$11512.poly VREF.$2.li1 0.0181392f
Cext_4167 PB.$11512.poly VREF.$4.li1 0.0181392f
Cext_4168 PB.$11512.poly VREF.$6.li1 0.0181392f
Cext_4169 PB.$11512.poly VREF.$63.met1 0.0110619f
Cext_4170 PB.$11512.poly VREF.$64.met1 0.0145873f
Cext_4171 PB.$11512.poly VREF.$65.met1 0.0150995f
Cext_4172 PB.$11512.poly VREF.$66.met1 0.0151301f
Cext_4173 PB.$11512.poly VREF.$67.met1 0.0141676f
Cext_4174 PB.$11512.poly VREF.$8.li1 0.0171523f
Cext_4175 PB.$11512.poly VREF.$85.met1 0.00334922f
Cext_4176 PB.$11512.poly sky130_gnd 0.179927f
Cext_4177 PB.$11513.poly VDD.$168.li1 0.00177361f
Cext_4178 PB.$11513.poly VDD.$170.li1 0.0171164f
Cext_4179 PB.$11513.poly VDD.$172.li1 0.0181392f
Cext_4180 PB.$11513.poly VDD.$174.li1 0.0181392f
Cext_4181 PB.$11513.poly VDD.$176.li1 0.0181392f
Cext_4182 PB.$11513.poly VDD.$178.li1 0.0172849f
Cext_4183 PB.$11513.poly VDD.$196.li1 0.00103443f
Cext_4184 PB.$11513.poly VDD.$197.li1 0.00103443f
Cext_4185 PB.$11513.poly VDD.$198.li1 0.00103443f
Cext_4186 PB.$11513.poly VDD.$199.li1 0.00103443f
Cext_4187 PB.$11513.poly VDD.$200.li1 0.00103443f
Cext_4188 PB.$11513.poly VDD.$411.met1 0.0141982f
Cext_4189 PB.$11513.poly VDD.$412.met1 0.0151301f
Cext_4190 PB.$11513.poly VDD.$413.met1 0.0151301f
Cext_4191 PB.$11513.poly VDD.$414.met1 0.0151301f
Cext_4192 PB.$11513.poly VDD.$415.met1 0.0136591f
Cext_4193 PB.$11513.poly VDD.$481.met2 0.0130041f
Cext_4194 PB.$11513.poly VDD.$502.met3 0.00524063f
Cext_4195 PB.$11513.poly VDD.$705.nwell 0.0669458f
Cext_4196 PB.$11513.poly VDD.$727.nwell 0.257593f
Cext_4197 PB.$11513.poly VREF.$32.li1 0.00177361f
Cext_4198 PB.$11513.poly VREF.$34.li1 0.0171609f
Cext_4199 PB.$11513.poly VREF.$36.li1 0.0181838f
Cext_4200 PB.$11513.poly VREF.$38.li1 0.0187975f
Cext_4201 PB.$11513.poly VREF.$40.li1 0.0181838f
Cext_4202 PB.$11513.poly VREF.$42.li1 0.0177317f
Cext_4203 PB.$11513.poly VREF.$80.met1 0.0143007f
Cext_4204 PB.$11513.poly VREF.$81.met1 0.0152326f
Cext_4205 PB.$11513.poly VREF.$82.met1 0.0152326f
Cext_4206 PB.$11513.poly VREF.$83.met1 0.0152326f
Cext_4207 PB.$11513.poly VREF.$84.met1 0.0151688f
Cext_4208 PB.$11513.poly sky130_gnd 0.179927f
Cext_4209 PB.$11534.poly VDD.$204.li1 0.0172849f
Cext_4210 PB.$11534.poly VDD.$206.li1 0.0181392f
Cext_4211 PB.$11534.poly VDD.$208.li1 0.0181392f
Cext_4212 PB.$11534.poly VDD.$210.li1 0.0181392f
Cext_4213 PB.$11534.poly VDD.$212.li1 0.0171164f
Cext_4214 PB.$11534.poly VDD.$214.li1 0.00177361f
Cext_4215 PB.$11534.poly VDD.$250.li1 0.00103443f
Cext_4216 PB.$11534.poly VDD.$251.li1 0.00103443f
Cext_4217 PB.$11534.poly VDD.$252.li1 0.00103443f
Cext_4218 PB.$11534.poly VDD.$253.li1 0.00103443f
Cext_4219 PB.$11534.poly VDD.$420.met1 0.0135496f
Cext_4220 PB.$11534.poly VDD.$421.met1 0.0150799f
Cext_4221 PB.$11534.poly VDD.$422.met1 0.0150995f
Cext_4222 PB.$11534.poly VDD.$423.met1 0.0151301f
Cext_4223 PB.$11534.poly VDD.$424.met1 0.0141676f
Cext_4224 PB.$11534.poly VDD.$485.met2 0.00990797f
Cext_4225 PB.$11534.poly VDD.$486.met2 0.00527466f
Cext_4226 PB.$11534.poly VDD.$488.met2 0.0023177f
Cext_4227 PB.$11534.poly VDD.$489.met2 0.00877976f
Cext_4228 PB.$11534.poly VDD.$503.met3 0.0522441f
Cext_4229 PB.$11534.poly VDD.$504.met3 0.00760479f
Cext_4230 PB.$11534.poly VDD.$706.nwell 0.0671955f
Cext_4231 PB.$11534.poly VDD.$728.nwell 0.258082f
Cext_4232 PB.$11534.poly VREF.$101.met2 0.00261994f
Cext_4233 PB.$11534.poly sky130_gnd 0.179927f
Cext_4234 PB.$11535.poly VDD.$236.li1 0.00177361f
Cext_4235 PB.$11535.poly VDD.$238.li1 0.0171164f
Cext_4236 PB.$11535.poly VDD.$240.li1 0.0181392f
Cext_4237 PB.$11535.poly VDD.$242.li1 0.0181392f
Cext_4238 PB.$11535.poly VDD.$244.li1 0.0181392f
Cext_4239 PB.$11535.poly VDD.$246.li1 0.0172849f
Cext_4240 PB.$11535.poly VDD.$264.li1 0.00103443f
Cext_4241 PB.$11535.poly VDD.$265.li1 0.00103443f
Cext_4242 PB.$11535.poly VDD.$266.li1 0.00103443f
Cext_4243 PB.$11535.poly VDD.$267.li1 0.00103443f
Cext_4244 PB.$11535.poly VDD.$268.li1 0.00103443f
Cext_4245 PB.$11535.poly VDD.$437.met1 0.0141982f
Cext_4246 PB.$11535.poly VDD.$438.met1 0.0151301f
Cext_4247 PB.$11535.poly VDD.$439.met1 0.0151301f
Cext_4248 PB.$11535.poly VDD.$440.met1 0.0151301f
Cext_4249 PB.$11535.poly VDD.$441.met1 0.0136591f
Cext_4250 PB.$11535.poly VDD.$727.nwell 0.0669458f
Cext_4251 PB.$11535.poly VDD.$749.nwell 0.256849f
Cext_4252 PB.$11535.poly sky130_gnd 0.18181f
Cext_4253 PB.$1184.capm VDD.$508.met3 3.26395f
Cext_4254 PB.$1184.capm VDD.P0.met3 20.8763f
Cext_4255 PB.$1258.capm VDD.$508.met3 3.31672f
Cext_4256 PB.$1258.capm VDD.P0.met3 20.8235f
Cext_4257 PB.$1332.capm VDD.$508.met3 3.36948f
Cext_4258 PB.$1332.capm VDD.P0.met3 20.7708f
Cext_4259 PB.$1406.capm VDD.$508.met3 3.42225f
Cext_4260 PB.$1406.capm VDD.P0.met3 20.718f
Cext_4261 PB.$148.capm VDD.$508.met3 2.52523f
Cext_4262 PB.$148.capm VDD.P0.met3 21.615f
Cext_4263 PB.$1480.capm VDD.$508.met3 3.47502f
Cext_4264 PB.$1480.capm VDD.P0.met3 20.6652f
Cext_4265 PB.$1554.capm VDD.$508.met3 3.52778f
Cext_4266 PB.$1554.capm VDD.P0.met3 20.6125f
Cext_4267 PB.$1628.capm VDD.$508.met3 3.58055f
Cext_4268 PB.$1628.capm VDD.P0.met3 20.5597f
Cext_4269 PB.$1702.capm VDD.$508.met3 3.63331f
Cext_4270 PB.$1702.capm VDD.P0.met3 20.5069f
Cext_4271 PB.$1776.capm VDD.$508.met3 3.68608f
Cext_4272 PB.$1776.capm VDD.P0.met3 20.4542f
Cext_4273 PB.$1850.capm VDD.$508.met3 3.73885f
Cext_4274 PB.$1850.capm VDD.P0.met3 20.4014f
Cext_4275 PB.$1924.capm VDD.$508.met3 3.79161f
Cext_4276 PB.$1924.capm VDD.P0.met3 20.3486f
Cext_4277 PB.$1998.capm VDD.$508.met3 3.84438f
Cext_4278 PB.$1998.capm VDD.P0.met3 20.2959f
Cext_4279 PB.$2072.capm VDD.$508.met3 3.89714f
Cext_4280 PB.$2072.capm VDD.P0.met3 20.2431f
Cext_4281 PB.$2146.capm VDD.$508.met3 3.94991f
Cext_4282 PB.$2146.capm VDD.P0.met3 20.1903f
Cext_4283 PB.$222.capm VDD.$508.met3 2.578f
Cext_4284 PB.$222.capm VDD.P0.met3 21.5623f
Cext_4285 PB.$2220.capm VDD.$508.met3 4.00268f
Cext_4286 PB.$2220.capm VDD.P0.met3 20.1376f
Cext_4287 PB.$2294.capm VDD.$508.met3 4.05544f
Cext_4288 PB.$2294.capm VDD.P0.met3 20.0848f
Cext_4289 PB.$2368.capm VDD.$508.met3 4.10821f
Cext_4290 PB.$2368.capm VDD.P0.met3 20.032f
Cext_4291 PB.$2442.capm VDD.$508.met3 4.16097f
Cext_4292 PB.$2442.capm VDD.P0.met3 19.9793f
Cext_4293 PB.$2516.capm VDD.$508.met3 4.21374f
Cext_4294 PB.$2516.capm VDD.P0.met3 19.9265f
Cext_4295 PB.$2590.capm VDD.$508.met3 4.26651f
Cext_4296 PB.$2590.capm VDD.P0.met3 19.8737f
Cext_4297 PB.$2664.capm VDD.$508.met3 4.31927f
Cext_4298 PB.$2664.capm VDD.P0.met3 19.741f
Cext_4299 PB.$2738.capm VDD.$508.met3 4.37204f
Cext_4300 PB.$2738.capm VDD.P0.met3 19.6882f
Cext_4301 PB.$2812.capm VDD.$508.met3 4.4248f
Cext_4302 PB.$2812.capm VDD.P0.met3 19.7154f
Cext_4303 PB.$2886.capm VDD.$508.met3 4.47757f
Cext_4304 PB.$2886.capm VDD.P0.met3 19.6627f
Cext_4305 PB.$296.capm VDD.$508.met3 2.63076f
Cext_4306 PB.$296.capm VDD.P0.met3 21.5095f
Cext_4307 PB.$2960.capm VDD.$508.met3 4.53034f
Cext_4308 PB.$2960.capm VDD.$511.met3 0.135211f
Cext_4309 PB.$2960.capm VDD.P0.met3 19.4747f
Cext_4310 PB.$3034.capm VDD.$508.met3 4.5831f
Cext_4311 PB.$3034.capm VDD.$511.met3 0.479335f
Cext_4312 PB.$3034.capm VDD.P0.met3 19.0778f
Cext_4313 PB.$3108.capm VDD.$508.met3 4.63587f
Cext_4314 PB.$3108.capm VDD.$511.met3 0.84736f
Cext_4315 PB.$3108.capm VDD.P0.met3 18.657f
Cext_4316 PB.$3182.capm VDD.$508.met3 4.68863f
Cext_4317 PB.$3182.capm VDD.$511.met3 1.22797f
Cext_4318 PB.$3182.capm VDD.P0.met3 18.2236f
Cext_4319 PB.$3256.capm VDD.$508.met3 4.7414f
Cext_4320 PB.$3256.capm VDD.$511.met3 1.62253f
Cext_4321 PB.$3256.capm VDD.P0.met3 17.7763f
Cext_4322 PB.$3330.capm VDD.$508.met3 4.79417f
Cext_4323 PB.$3330.capm VDD.$511.met3 2.03248f
Cext_4324 PB.$3330.capm VDD.P0.met3 17.3136f
Cext_4325 PB.$3404.capm VDD.$508.met3 4.84693f
Cext_4326 PB.$3404.capm VDD.$511.met3 2.45972f
Cext_4327 PB.$3404.capm VDD.P0.met3 16.8336f
Cext_4328 PB.$3478.capm VDD.$508.met3 4.8997f
Cext_4329 PB.$3478.capm VDD.$511.met3 2.90729f
Cext_4330 PB.$3478.capm VDD.P0.met3 16.3333f
Cext_4331 PB.$3552.capm VDD.$508.met3 4.95246f
Cext_4332 PB.$3552.capm VDD.$511.met3 3.37751f
Cext_4333 PB.$3552.capm VDD.P0.met3 15.8103f
Cext_4334 PB.$3626.capm VDD.$508.met3 5.00523f
Cext_4335 PB.$3626.capm VDD.$511.met3 3.87504f
Cext_4336 PB.$3626.capm VDD.P0.met3 15.26f
Cext_4337 PB.$370.capm VDD.$508.met3 2.68353f
Cext_4338 PB.$370.capm VDD.P0.met3 21.4567f
Cext_4339 PB.$3700.capm VDD.$508.met3 5.058f
Cext_4340 PB.$3700.capm VDD.$511.met3 4.40446f
Cext_4341 PB.$3700.capm VDD.P0.met3 14.6778f
Cext_4342 PB.$3774.capm VDD.$508.met3 5.09724f
Cext_4343 PB.$3774.capm VDD.$511.met3 5.00444f
Cext_4344 PB.$3774.capm VDD.P0.met3 14.0394f
Cext_4345 PB.$3848.capm VDD.$508.met3 4.8036f
Cext_4346 PB.$3848.capm VDD.$511.met3 6.38173f
Cext_4347 PB.$3848.capm VDD.P0.met3 12.9549f
Cext_4348 PB.$3922.capm VDD.$508.met3 4.35254f
Cext_4349 PB.$3922.capm VDD.$511.met3 8.20306f
Cext_4350 PB.$3922.capm VDD.P0.met3 11.5847f
Cext_4351 PB.$3996.capm VDD.$508.met3 3.87135f
Cext_4352 PB.$3996.capm VDD.$511.met3 10.2407f
Cext_4353 PB.$3996.capm VDD.P0.met3 10.0282f
Cext_4354 PB.$4070.capm VDD.$508.met3 3.35397f
Cext_4355 PB.$4070.capm VDD.$511.met3 12.6098f
Cext_4356 PB.$4070.capm VDD.P0.met3 8.17643f
Cext_4357 PB.$4144.capm VDD.$508.met3 2.79006f
Cext_4358 PB.$4144.capm VDD.$511.met3 15.6152f
Cext_4359 PB.$4144.capm VDD.P0.met3 5.73502f
Cext_4360 PB.$4218.capm VDD.$508.met3 2.1642f
Cext_4361 PB.$4218.capm VDD.$511.met3 20.606f
Cext_4362 PB.$4218.capm VDD.P0.met3 1.37008f
Cext_4363 PB.$4292.capm VDD.$508.met3 1.4501f
Cext_4364 PB.$4292.capm VDD.$511.met3 22.6901f
Cext_4365 PB.$4366.capm VDD.$508.met3 0.593831f
Cext_4366 PB.$4366.capm VDD.$511.met3 23.5464f
Cext_4367 PB.$444.capm VDD.$508.met3 2.73629f
Cext_4368 PB.$444.capm VDD.P0.met3 21.404f
Cext_4369 PB.$4440.capm VDD.$508.met3 0.0070368f
Cext_4370 PB.$4440.capm VDD.$511.met3 24.1332f
Cext_4371 PB.$4514.capm VDD.$511.met3 24.1402f
Cext_4372 PB.$4588.capm VDD.$511.met3 24.1402f
Cext_4373 PB.$4662.capm VDD.$511.met3 24.1402f
Cext_4374 PB.$4736.capm VDD.$511.met3 24.1402f
Cext_4375 PB.$4810.capm VDD.$511.met3 24.1402f
Cext_4376 PB.$4810.capm VDD.$587.met4 0.00367303f
Cext_4377 PB.$4810.capm VDD.$661.met4 0.00492995f
Cext_4378 PB.$4884.capm VDD.$511.met3 24.1402f
Cext_4379 PB.$4958.capm VDD.$511.met3 24.1402f
Cext_4380 PB.$5032.capm VDD.$511.met3 24.1402f
Cext_4381 PB.$5106.capm VDD.$511.met3 24.1402f
Cext_4382 PB.$518.capm VDD.$508.met3 2.78906f
Cext_4383 PB.$518.capm VDD.P0.met3 21.3512f
Cext_4384 PB.$5180.capm VDD.$511.met3 24.1402f
Cext_4385 PB.$5254.capm VDD.$511.met3 24.1402f
Cext_4386 PB.$5328.capm VDD.$511.met3 24.1402f
Cext_4387 PB.$5402.capm VDD 0.00311026f
Cext_4388 PB.$5402.capm VDD.$511.met3 41.867f
Cext_4389 PB.$5402.capm VDD.$587.met4 0.00201623f
Cext_4390 PB.$5402.capm VDD.$588.met4 0.0039851f
Cext_4391 PB.$5402.capm VDD.$589.met4 0.0039851f
Cext_4392 PB.$5402.capm VDD.$590.met4 0.00256916f
Cext_4393 PB.$5402.capm VDD.$591.met4 0.00540104f
Cext_4394 PB.$5402.capm VDD.$592.met4 0.00256916f
Cext_4395 PB.$5402.capm VDD.$593.met4 0.0039851f
Cext_4396 PB.$5402.capm VDD.$594.met4 0.0039851f
Cext_4397 PB.$5402.capm VDD.$595.met4 0.00256916f
Cext_4398 PB.$5402.capm VDD.$596.met4 0.00540104f
Cext_4399 PB.$5402.capm VDD.$597.met4 0.00256916f
Cext_4400 PB.$5402.capm VDD.$598.met4 0.0039851f
Cext_4401 PB.$5402.capm VDD.$599.met4 0.0039851f
Cext_4402 PB.$5402.capm VDD.$600.met4 0.00256916f
Cext_4403 PB.$5402.capm VDD.$601.met4 0.00540104f
Cext_4404 PB.$5402.capm VDD.$602.met4 0.00256916f
Cext_4405 PB.$5402.capm VDD.$603.met4 0.0039851f
Cext_4406 PB.$5402.capm VDD.$604.met4 0.0039851f
Cext_4407 PB.$5402.capm VDD.$605.met4 0.00256916f
Cext_4408 PB.$5402.capm VDD.$606.met4 0.00540104f
Cext_4409 PB.$5402.capm VDD.$607.met4 0.00256916f
Cext_4410 PB.$5402.capm VDD.$608.met4 0.0039851f
Cext_4411 PB.$5402.capm VDD.$609.met4 0.0039851f
Cext_4412 PB.$5402.capm VDD.$610.met4 0.00256916f
Cext_4413 PB.$5402.capm VDD.$611.met4 0.00540104f
Cext_4414 PB.$5402.capm VDD.$612.met4 0.00256916f
Cext_4415 PB.$5402.capm VDD.$613.met4 0.0039851f
Cext_4416 PB.$5402.capm VDD.$614.met4 0.0039851f
Cext_4417 PB.$5402.capm VDD.$615.met4 0.00256916f
Cext_4418 PB.$5402.capm VDD.$616.met4 0.00540104f
Cext_4419 PB.$5402.capm VDD.$617.met4 0.00256916f
Cext_4420 PB.$5402.capm VDD.$618.met4 0.0039851f
Cext_4421 PB.$5402.capm VDD.$619.met4 0.0039851f
Cext_4422 PB.$5402.capm VDD.$620.met4 0.00256916f
Cext_4423 PB.$5402.capm VDD.$621.met4 0.00540104f
Cext_4424 PB.$5402.capm VDD.$622.met4 0.00256916f
Cext_4425 PB.$5402.capm VDD.$623.met4 0.0039851f
Cext_4426 PB.$5402.capm VDD.$624.met4 0.0039851f
Cext_4427 PB.$5402.capm VDD.$625.met4 0.00256916f
Cext_4428 PB.$5402.capm VDD.$626.met4 0.00540104f
Cext_4429 PB.$5402.capm VDD.$627.met4 0.00256916f
Cext_4430 PB.$5402.capm VDD.$628.met4 0.0039851f
Cext_4431 PB.$5402.capm VDD.$629.met4 0.0039851f
Cext_4432 PB.$5402.capm VDD.$630.met4 0.00256916f
Cext_4433 PB.$5402.capm VDD.$631.met4 0.00540104f
Cext_4434 PB.$5402.capm VDD.$632.met4 0.00256916f
Cext_4435 PB.$5402.capm VDD.$633.met4 0.0039851f
Cext_4436 PB.$5402.capm VDD.$634.met4 0.0039851f
Cext_4437 PB.$5402.capm VDD.$635.met4 0.00256916f
Cext_4438 PB.$5402.capm VDD.$636.met4 0.00540104f
Cext_4439 PB.$5402.capm VDD.$637.met4 0.00256916f
Cext_4440 PB.$5402.capm VDD.$638.met4 0.0039851f
Cext_4441 PB.$5402.capm VDD.$639.met4 0.0039851f
Cext_4442 PB.$5402.capm VDD.$640.met4 0.00256916f
Cext_4443 PB.$5402.capm VDD.$641.met4 0.00540104f
Cext_4444 PB.$5402.capm VDD.$642.met4 0.00256916f
Cext_4445 PB.$5402.capm VDD.$643.met4 0.0039851f
Cext_4446 PB.$5402.capm VDD.$644.met4 0.0039851f
Cext_4447 PB.$5402.capm VDD.$645.met4 0.00256916f
Cext_4448 PB.$5402.capm VDD.$646.met4 0.00540104f
Cext_4449 PB.$5402.capm VDD.$647.met4 0.00256916f
Cext_4450 PB.$5402.capm VDD.$648.met4 0.0039851f
Cext_4451 PB.$5402.capm VDD.$649.met4 0.0039851f
Cext_4452 PB.$5402.capm VDD.$650.met4 0.00256916f
Cext_4453 PB.$5402.capm VDD.$651.met4 0.00540104f
Cext_4454 PB.$5402.capm VDD.$652.met4 0.00256916f
Cext_4455 PB.$5402.capm VDD.$653.met4 0.0039851f
Cext_4456 PB.$5402.capm VDD.$654.met4 0.0039851f
Cext_4457 PB.$5402.capm VDD.$655.met4 0.00256916f
Cext_4458 PB.$5402.capm VDD.$656.met4 0.00540104f
Cext_4459 PB.$5402.capm VDD.$657.met4 0.00256916f
Cext_4460 PB.$5402.capm VDD.$658.met4 0.00337537f
Cext_4461 PB.$5402.capm VDD.$659.met4 0.00342105f
Cext_4462 PB.$5402.capm VDD.$660.met4 0.00406791f
Cext_4463 PB.$5402.capm VDD.$661.met4 0.00389352f
Cext_4464 PB.$5476.li1 VDD.$662.nwell 0.0033535f
Cext_4465 PB.$5476.li1 sky130_gnd 0.0154221f
Cext_4466 PB.$5478.li1 VDD.$683.nwell 0.0033535f
Cext_4467 PB.$5478.li1 sky130_gnd 0.0168085f
Cext_4468 PB.$5480.li1 VDD.$662.nwell 0.00144114f
Cext_4469 PB.$5480.li1 sky130_gnd 0.0111475f
Cext_4470 PB.$5482.li1 VDD.$683.nwell 0.00144114f
Cext_4471 PB.$5482.li1 sky130_gnd 0.0125941f
Cext_4472 PB.$5484.li1 VDD.$662.nwell 0.00144114f
Cext_4473 PB.$5484.li1 sky130_gnd 0.0111475f
Cext_4474 PB.$5486.li1 VDD.$683.nwell 0.00144114f
Cext_4475 PB.$5486.li1 sky130_gnd 0.0125941f
Cext_4476 PB.$5488.li1 VDD.$662.nwell 0.00144114f
Cext_4477 PB.$5488.li1 sky130_gnd 0.0111475f
Cext_4478 PB.$5490.li1 VDD.$683.nwell 0.00144114f
Cext_4479 PB.$5490.li1 sky130_gnd 0.0125941f
Cext_4480 PB.$5492.li1 VDD.$662.nwell 0.00144114f
Cext_4481 PB.$5492.li1 sky130_gnd 0.0111475f
Cext_4482 PB.$5494.li1 VDD.$683.nwell 0.00144114f
Cext_4483 PB.$5494.li1 sky130_gnd 0.0125941f
Cext_4484 PB.$5496.li1 VDD.$662.nwell 0.00144114f
Cext_4485 PB.$5496.li1 sky130_gnd 0.0111475f
Cext_4486 PB.$5498.li1 VDD.$683.nwell 0.00144114f
Cext_4487 PB.$5498.li1 sky130_gnd 0.0125941f
Cext_4488 PB.$5500.li1 VDD.$662.nwell 0.00144114f
Cext_4489 PB.$5500.li1 sky130_gnd 0.0111475f
Cext_4490 PB.$5502.li1 VDD.$683.nwell 0.00144114f
Cext_4491 PB.$5502.li1 sky130_gnd 0.0125941f
Cext_4492 PB.$5504.li1 VDD.$662.nwell 0.00144114f
Cext_4493 PB.$5504.li1 sky130_gnd 0.0111475f
Cext_4494 PB.$5506.li1 VDD.$683.nwell 0.00144114f
Cext_4495 PB.$5506.li1 sky130_gnd 0.0125941f
Cext_4496 PB.$5508.li1 VDD.$662.nwell 0.00144114f
Cext_4497 PB.$5508.li1 sky130_gnd 0.0111475f
Cext_4498 PB.$5510.li1 VDD.$683.nwell 0.00144114f
Cext_4499 PB.$5510.li1 sky130_gnd 0.0125941f
Cext_4500 PB.$5512.li1 VDD.$662.nwell 0.00144114f
Cext_4501 PB.$5512.li1 sky130_gnd 0.0111475f
Cext_4502 PB.$5514.li1 VDD.$683.nwell 0.00144114f
Cext_4503 PB.$5514.li1 sky130_gnd 0.0125941f
Cext_4504 PB.$5516.li1 VDD.$662.nwell 0.00461705f
Cext_4505 PB.$5516.li1 sky130_gnd 0.0132826f
Cext_4506 PB.$5518.li1 VDD.$683.nwell 0.00469712f
Cext_4507 PB.$5518.li1 sky130_gnd 0.0145347f
Cext_4508 PB.$5520.li1 VDD.$662.nwell 0.0039313f
Cext_4509 PB.$5520.li1 sky130_gnd 0.0139141f
Cext_4510 PB.$5522.li1 VDD.$683.nwell 0.0039313f
Cext_4511 PB.$5522.li1 sky130_gnd 0.0153005f
Cext_4512 PB.$5524.li1 VDD.$662.nwell 0.00126099f
Cext_4513 PB.$5524.li1 sky130_gnd 0.0111475f
Cext_4514 PB.$5526.li1 VDD.$683.nwell 0.00126099f
Cext_4515 PB.$5526.li1 sky130_gnd 0.0125941f
Cext_4516 PB.$5528.li1 VDD.$684.nwell 0.00144114f
Cext_4517 PB.$5528.li1 sky130_gnd 0.0111475f
Cext_4518 PB.$5530.li1 VDD.$705.nwell 0.00144114f
Cext_4519 PB.$5530.li1 sky130_gnd 0.0125941f
Cext_4520 PB.$5532.li1 VDD.$684.nwell 0.00144114f
Cext_4521 PB.$5532.li1 sky130_gnd 0.0111475f
Cext_4522 PB.$5534.li1 VDD.$705.nwell 0.00144114f
Cext_4523 PB.$5534.li1 sky130_gnd 0.0125941f
Cext_4524 PB.$5536.li1 VDD.$684.nwell 0.00144114f
Cext_4525 PB.$5536.li1 sky130_gnd 0.0111475f
Cext_4526 PB.$5538.li1 VDD.$705.nwell 0.00144114f
Cext_4527 PB.$5538.li1 sky130_gnd 0.0125941f
Cext_4528 PB.$5540.li1 VDD.$684.nwell 0.00144114f
Cext_4529 PB.$5540.li1 sky130_gnd 0.0111475f
Cext_4530 PB.$5542.li1 VDD.$705.nwell 0.00144114f
Cext_4531 PB.$5542.li1 sky130_gnd 0.0125941f
Cext_4532 PB.$5544.li1 VDD.$684.nwell 0.00144114f
Cext_4533 PB.$5544.li1 sky130_gnd 0.0111475f
Cext_4534 PB.$5546.li1 VDD.$705.nwell 0.00144114f
Cext_4535 PB.$5546.li1 sky130_gnd 0.0125941f
Cext_4536 PB.$5548.li1 VDD.$684.nwell 0.00144114f
Cext_4537 PB.$5548.li1 sky130_gnd 0.0111475f
Cext_4538 PB.$5550.li1 VDD.$705.nwell 0.00144114f
Cext_4539 PB.$5550.li1 sky130_gnd 0.0125941f
Cext_4540 PB.$5552.li1 VDD.$684.nwell 0.00144114f
Cext_4541 PB.$5552.li1 sky130_gnd 0.0111475f
Cext_4542 PB.$5554.li1 VDD.$705.nwell 0.00144114f
Cext_4543 PB.$5554.li1 sky130_gnd 0.0125941f
Cext_4544 PB.$5556.li1 VDD.$684.nwell 0.00136107f
Cext_4545 PB.$5556.li1 sky130_gnd 0.0112401f
Cext_4546 PB.$5558.li1 VDD.$705.nwell 0.00144114f
Cext_4547 PB.$5558.li1 sky130_gnd 0.0125941f
Cext_4548 PB.$5560.li1 TAIL.$340.met3 0.00102372f
Cext_4549 PB.$5560.li1 TAIL.$88.li1 0.00103015f
Cext_4550 PB.$5560.li1 VSS.$14.li1 0.0140995f
Cext_4551 PB.$5560.li1 VSS.$16.li1 0.00161596f
Cext_4552 PB.$5560.li1 sky130_gnd 0.00657328f
Cext_4553 PB.$5562.li1 TAIL.$340.met3 0.00379223f
Cext_4554 PB.$5562.li1 TAIL.$90.li1 0.00107494f
Cext_4555 PB.$5562.li1 VSS.$16.li1 0.0136434f
Cext_4556 PB.$5562.li1 VSS.$18.li1 0.00159301f
Cext_4557 PB.$5564.li1 TAIL.$92.li1 0.00107494f
Cext_4558 PB.$5564.li1 VSS.$18.li1 0.0137831f
Cext_4559 PB.$5564.li1 VSS.$20.li1 0.00166186f
Cext_4560 PB.$5566.li1 TAIL.$94.li1 0.00107494f
Cext_4561 PB.$5566.li1 VSS.$20.li1 0.0140231f
Cext_4562 PB.$5566.li1 VSS.$22.li1 0.00166186f
Cext_4563 PB.$5568.li1 TAIL.$96.li1 0.00108913f
Cext_4564 PB.$5568.li1 VSS.$22.li1 0.0140231f
Cext_4565 PB.$5568.li1 VSS.$24.li1 0.00166186f
Cext_4566 PB.$5570.li1 TAIL.$98.li1 0.0011479f
Cext_4567 PB.$5570.li1 VSS.$24.li1 0.0142067f
Cext_4568 PB.$5570.li1 VSS.$26.li1 0.00147826f
Cext_4569 PB.$5572.li1 TAIL.$100.li1 0.0011479f
Cext_4570 PB.$5572.li1 VSS.$242.met1 0.00146879f
Cext_4571 PB.$5572.li1 VSS.$26.li1 0.0125132f
Cext_4572 PB.$5572.li1 VSS.$28.li1 0.00147826f
Cext_4573 PB.$5574.li1 TAIL.$102.li1 0.0011479f
Cext_4574 PB.$5574.li1 VSS.$243.met1 0.00146879f
Cext_4575 PB.$5574.li1 VSS.$28.li1 0.0125132f
Cext_4576 PB.$5574.li1 VSS.$30.li1 0.00147826f
Cext_4577 PB.$5576.li1 TAIL.$104.li1 0.0011479f
Cext_4578 PB.$5576.li1 VSS.$244.met1 0.00146879f
Cext_4579 PB.$5576.li1 VSS.$30.li1 0.0125132f
Cext_4580 PB.$5576.li1 VSS.$32.li1 0.00147826f
Cext_4581 PB.$5578.li1 TAIL.$106.li1 0.00111548f
Cext_4582 PB.$5578.li1 VSS.$245.met1 0.00146879f
Cext_4583 PB.$5578.li1 VSS.$32.li1 0.0125132f
Cext_4584 PB.$5578.li1 VSS.$34.li1 0.00147826f
Cext_4585 PB.$5580.li1 TAIL.$108.li1 0.0011398f
Cext_4586 PB.$5580.li1 VSS.$34.li1 0.0139131f
Cext_4587 PB.$5580.li1 VSS.$36.li1 0.00147826f
Cext_4588 PB.$5582.li1 TAIL.$110.li1 0.0011479f
Cext_4589 PB.$5582.li1 VSS.$247.met1 0.00117044f
Cext_4590 PB.$5582.li1 VSS.$36.li1 0.0127427f
Cext_4591 PB.$5582.li1 VSS.$38.li1 0.00147826f
Cext_4592 PB.$5584.li1 TAIL.$112.li1 0.0011479f
Cext_4593 PB.$5584.li1 VSS.$248.met1 0.00146879f
Cext_4594 PB.$5584.li1 VSS.$38.li1 0.0125132f
Cext_4595 PB.$5584.li1 VSS.$40.li1 0.00147826f
Cext_4596 PB.$5586.li1 TAIL.$114.li1 0.0011479f
Cext_4597 PB.$5586.li1 VSS.$40.li1 0.0134785f
Cext_4598 PB.$5586.li1 VSS.$42.li1 0.00147826f
Cext_4599 PB.$5588.li1 TAIL.$116.li1 0.0011479f
Cext_4600 PB.$5588.li1 VSS.$13.li1 0.00439348f
Cext_4601 PB.$5588.li1 VSS.$377.met2 0.00165239f
Cext_4602 PB.$5588.li1 VSS.$42.li1 0.00941437f
Cext_4603 PB.$5590.li1 TAIL.$118.li1 0.0011479f
Cext_4604 PB.$5590.li1 VSS.$13.li1 0.0133043f
Cext_4605 PB.$5590.li1 VSS.$377.met2 0.00165239f
Cext_4606 PB.$5592.li1 TAIL.$120.li1 0.0011479f
Cext_4607 PB.$5592.li1 VSS.$13.li1 0.0133043f
Cext_4608 PB.$5592.li1 VSS.$377.met2 0.00165239f
Cext_4609 PB.$5594.li1 TAIL.$122.li1 0.0011479f
Cext_4610 PB.$5594.li1 VSS.$13.li1 0.0133043f
Cext_4611 PB.$5594.li1 VSS.$377.met2 0.00165239f
Cext_4612 PB.$5596.li1 TAIL.$124.li1 0.0011479f
Cext_4613 PB.$5596.li1 VSS.$13.li1 0.0133043f
Cext_4614 PB.$5596.li1 VSS.$377.met2 0.00165239f
Cext_4615 PB.$5598.li1 TAIL.$126.li1 0.0011479f
Cext_4616 PB.$5598.li1 VSS.$13.li1 0.0133043f
Cext_4617 PB.$5598.li1 VSS.$377.met2 0.00165239f
Cext_4618 PB.$5600.li1 TAIL.$128.li1 0.00108102f
Cext_4619 PB.$5600.li1 VSS.$13.li1 0.0149567f
Cext_4620 PB.$5600.li1 VSS.$417.met3 0.00374382f
Cext_4621 PB.$5602.li1 TAIL.$130.li1 0.00107494f
Cext_4622 PB.$5602.li1 VSS.$13.li1 0.0147961f
Cext_4623 PB.$5602.li1 VSS.$417.met3 0.00155717f
Cext_4624 PB.$5604.li1 TAIL.$132.li1 0.00109116f
Cext_4625 PB.$5604.li1 VSS.$13.li1 0.0148879f
Cext_4626 PB.$5606.li1 TAIL.$134.li1 0.00113068f
Cext_4627 PB.$5606.li1 VSS.$13.li1 0.0149567f
Cext_4628 PB.$5608.li1 TAIL.$136.li1 0.0011479f
Cext_4629 PB.$5608.li1 VSS.$13.li1 0.0149567f
Cext_4630 PB.$5610.li1 TAIL.$138.li1 0.0011479f
Cext_4631 PB.$5610.li1 VSS.$13.li1 0.0149567f
Cext_4632 PB.$5612.li1 TAIL.$140.li1 0.0011479f
Cext_4633 PB.$5612.li1 VSS.$13.li1 0.0149567f
Cext_4634 PB.$5614.li1 TAIL.$142.li1 0.0011479f
Cext_4635 PB.$5614.li1 VSS.$13.li1 0.0149567f
Cext_4636 PB.$5616.li1 TAIL.$144.li1 0.0011479f
Cext_4637 PB.$5616.li1 VSS.$13.li1 0.0149567f
Cext_4638 PB.$5618.li1 TAIL.$146.li1 0.0011479f
Cext_4639 PB.$5618.li1 VSS.$13.li1 0.0149567f
Cext_4640 PB.$5620.li1 TAIL.$148.li1 0.0011479f
Cext_4641 PB.$5620.li1 VSS.$13.li1 0.0149567f
Cext_4642 PB.$5622.li1 TAIL.$150.li1 0.0011479f
Cext_4643 PB.$5622.li1 VSS.$13.li1 0.0149567f
Cext_4644 PB.$5624.li1 TAIL.$152.li1 0.0011479f
Cext_4645 PB.$5624.li1 VSS.$13.li1 0.0149567f
Cext_4646 PB.$5626.li1 TAIL.$154.li1 0.0011479f
Cext_4647 PB.$5626.li1 VSS.$13.li1 0.0149567f
Cext_4648 PB.$5628.li1 TAIL.$156.li1 0.0011479f
Cext_4649 PB.$5628.li1 VSS.$13.li1 0.0149567f
Cext_4650 PB.$5630.li1 TAIL.$158.li1 0.0011479f
Cext_4651 PB.$5630.li1 VSS.$13.li1 0.0149567f
Cext_4652 PB.$5632.li1 TAIL.$160.li1 0.0011479f
Cext_4653 PB.$5632.li1 VSS.$13.li1 0.0149567f
Cext_4654 PB.$5634.li1 TAIL.$162.li1 0.0011479f
Cext_4655 PB.$5634.li1 VSS.$13.li1 0.0149567f
Cext_4656 PB.$5636.li1 TAIL.$164.li1 0.0011479f
Cext_4657 PB.$5636.li1 VSS.$13.li1 0.0149567f
Cext_4658 PB.$5638.li1 TAIL.$166.li1 0.0011479f
Cext_4659 PB.$5638.li1 VSS.$13.li1 0.0149567f
Cext_4660 PB.$5640.li1 TAIL.$168.li1 0.0011479f
Cext_4661 PB.$5640.li1 VSS.$13.li1 0.0149567f
Cext_4662 PB.$5642.li1 TAIL.$170.li1 0.0011479f
Cext_4663 PB.$5642.li1 VSS.$13.li1 0.0149567f
Cext_4664 PB.$5644.li1 TAIL.$172.li1 0.0011479f
Cext_4665 PB.$5644.li1 VSS.$13.li1 0.0149567f
Cext_4666 PB.$5646.li1 TAIL.$174.li1 0.00109602f
Cext_4667 PB.$5646.li1 VSS.$13.li1 0.0142417f
Cext_4668 PB.$5646.li1 sky130_gnd 0.00599931f
Cext_4669 PB.$5648.li1 VDD.$684.nwell 0.00469712f
Cext_4670 PB.$5648.li1 sky130_gnd 0.013468f
Cext_4671 PB.$5650.li1 VDD.$705.nwell 0.00469712f
Cext_4672 PB.$5650.li1 sky130_gnd 0.0145347f
Cext_4673 PB.$5652.li1 VDD.$483.met2 0.00532512f
Cext_4674 PB.$5652.li1 VDD.$684.nwell 0.0039313f
Cext_4675 PB.$5652.li1 sky130_gnd 0.0153005f
Cext_4676 PB.$5654.li1 VDD.$705.nwell 0.0039313f
Cext_4677 PB.$5654.li1 sky130_gnd 0.0153005f
Cext_4678 PB.$5656.li1 VDD.$684.nwell 0.00126099f
Cext_4679 PB.$5656.li1 sky130_gnd 0.0125941f
Cext_4680 PB.$5658.li1 VDD.$705.nwell 0.00126099f
Cext_4681 PB.$5658.li1 sky130_gnd 0.0125941f
Cext_4682 PB.$5660.li1 VDD.$706.nwell 0.00144114f
Cext_4683 PB.$5660.li1 sky130_gnd 0.0125941f
Cext_4684 PB.$5662.li1 VDD.$727.nwell 0.00144114f
Cext_4685 PB.$5662.li1 sky130_gnd 0.0125941f
Cext_4686 PB.$5664.li1 VDD.$706.nwell 0.00144114f
Cext_4687 PB.$5664.li1 sky130_gnd 0.0125941f
Cext_4688 PB.$5666.li1 VDD.$727.nwell 0.00144114f
Cext_4689 PB.$5666.li1 sky130_gnd 0.0125941f
Cext_4690 PB.$5668.li1 VDD.$706.nwell 0.00144114f
Cext_4691 PB.$5668.li1 sky130_gnd 0.0125941f
Cext_4692 PB.$5670.li1 VDD.$727.nwell 0.00144114f
Cext_4693 PB.$5670.li1 sky130_gnd 0.0125941f
Cext_4694 PB.$5672.li1 VDD.$706.nwell 0.00144114f
Cext_4695 PB.$5672.li1 sky130_gnd 0.0125941f
Cext_4696 PB.$5674.li1 VDD.$727.nwell 0.00144114f
Cext_4697 PB.$5674.li1 sky130_gnd 0.0125941f
Cext_4698 PB.$5676.li1 VDD.$706.nwell 0.00144114f
Cext_4699 PB.$5676.li1 sky130_gnd 0.0125941f
Cext_4700 PB.$5678.li1 VDD.$727.nwell 0.00144114f
Cext_4701 PB.$5678.li1 sky130_gnd 0.0125941f
Cext_4702 PB.$5680.li1 VDD.$706.nwell 0.00144114f
Cext_4703 PB.$5680.li1 sky130_gnd 0.0125941f
Cext_4704 PB.$5682.li1 VDD.$727.nwell 0.00144114f
Cext_4705 PB.$5682.li1 sky130_gnd 0.0125941f
Cext_4706 PB.$5684.li1 VDD.$706.nwell 0.00144114f
Cext_4707 PB.$5684.li1 sky130_gnd 0.0125941f
Cext_4708 PB.$5686.li1 VDD.$727.nwell 0.00144114f
Cext_4709 PB.$5686.li1 sky130_gnd 0.0125941f
Cext_4710 PB.$5688.li1 VDD.$706.nwell 0.00144114f
Cext_4711 PB.$5688.li1 sky130_gnd 0.0125941f
Cext_4712 PB.$5690.li1 VDD.$727.nwell 0.00144114f
Cext_4713 PB.$5690.li1 sky130_gnd 0.0125941f
Cext_4714 PB.$5692.li1 VDD.$706.nwell 0.00469712f
Cext_4715 PB.$5692.li1 sky130_gnd 0.0145347f
Cext_4716 PB.$5694.li1 VDD.$727.nwell 0.00469712f
Cext_4717 PB.$5694.li1 sky130_gnd 0.0145347f
Cext_4718 PB.$5696.li1 VDD.$706.nwell 0.0039313f
Cext_4719 PB.$5696.li1 sky130_gnd 0.0153005f
Cext_4720 PB.$5698.li1 VDD.$727.nwell 0.0039313f
Cext_4721 PB.$5698.li1 sky130_gnd 0.0153005f
Cext_4722 PB.$5700.li1 VDD.$706.nwell 0.00126099f
Cext_4723 PB.$5700.li1 sky130_gnd 0.0125941f
Cext_4724 PB.$5702.li1 VDD.$727.nwell 0.00126099f
Cext_4725 PB.$5702.li1 sky130_gnd 0.0125941f
Cext_4726 PB.$5704.li1 VDD.$728.nwell 0.00144114f
Cext_4727 PB.$5704.li1 sky130_gnd 0.0125941f
Cext_4728 PB.$5706.li1 VDD.$749.nwell 0.00144114f
Cext_4729 PB.$5706.li1 sky130_gnd 0.0125941f
Cext_4730 PB.$5708.li1 VDD.$728.nwell 0.00144114f
Cext_4731 PB.$5708.li1 sky130_gnd 0.0125941f
Cext_4732 PB.$5710.li1 VDD.$749.nwell 0.00144114f
Cext_4733 PB.$5710.li1 sky130_gnd 0.0125941f
Cext_4734 PB.$5712.li1 VDD.$728.nwell 0.00144114f
Cext_4735 PB.$5712.li1 sky130_gnd 0.0125941f
Cext_4736 PB.$5714.li1 VDD.$749.nwell 0.00144114f
Cext_4737 PB.$5714.li1 sky130_gnd 0.0125941f
Cext_4738 PB.$5716.li1 VDD.$728.nwell 0.00144114f
Cext_4739 PB.$5716.li1 sky130_gnd 0.0125941f
Cext_4740 PB.$5718.li1 VDD.$749.nwell 0.00144114f
Cext_4741 PB.$5718.li1 sky130_gnd 0.0125941f
Cext_4742 PB.$5720.li1 VDD.$728.nwell 0.00144114f
Cext_4743 PB.$5720.li1 sky130_gnd 0.0125941f
Cext_4744 PB.$5722.li1 VDD.$749.nwell 0.00144114f
Cext_4745 PB.$5722.li1 sky130_gnd 0.0125941f
Cext_4746 PB.$5724.li1 VDD.$728.nwell 0.00144114f
Cext_4747 PB.$5724.li1 sky130_gnd 0.0125941f
Cext_4748 PB.$5726.li1 VDD.$749.nwell 0.00144114f
Cext_4749 PB.$5726.li1 sky130_gnd 0.0125941f
Cext_4750 PB.$5728.li1 VDD.$728.nwell 0.00144114f
Cext_4751 PB.$5728.li1 sky130_gnd 0.0125941f
Cext_4752 PB.$5730.li1 VDD.$749.nwell 0.00144114f
Cext_4753 PB.$5730.li1 sky130_gnd 0.0125941f
Cext_4754 PB.$5732.li1 VDD.$728.nwell 0.00144114f
Cext_4755 PB.$5732.li1 sky130_gnd 0.0125941f
Cext_4756 PB.$5734.li1 VDD.$749.nwell 0.00144114f
Cext_4757 PB.$5734.li1 sky130_gnd 0.0125941f
Cext_4758 PB.$5736.li1 VDD.$728.nwell 0.00469712f
Cext_4759 PB.$5736.li1 sky130_gnd 0.0145347f
Cext_4760 PB.$5738.li1 VDD.$749.nwell 0.00438357f
Cext_4761 PB.$5738.li1 sky130_gnd 0.0157784f
Cext_4762 PB.$5740.li1 S.P0.poly 0.0130179f
Cext_4763 PB.$5740.li1 VSS.$117.li1 0.00344979f
Cext_4764 PB.$5740.li1 VSS.$119.li1 0.0148073f
Cext_4765 PB.$5740.li1 sky130_gnd 0.0135103f
Cext_4766 PB.$5742.li1 VDD.$306.li1 0.00103015f
Cext_4767 PB.$5742.li1 VDD.$328.li1 0.0155213f
Cext_4768 PB.$5742.li1 VDD.$761.nwell 0.00238369f
Cext_4769 PB.$5742.li1 sky130_gnd 0.00440788f
Cext_4770 PB.$5744.li1 VDD.$308.li1 0.00107494f
Cext_4771 PB.$5744.li1 VDD.$329.li1 0.0172359f
Cext_4772 PB.$5746.li1 VDD.$310.li1 0.00107494f
Cext_4773 PB.$5746.li1 VDD.$330.li1 0.0166429f
Cext_4774 PB.$5748.li1 VDD.$312.li1 0.00107494f
Cext_4775 PB.$5748.li1 VDD.$331.li1 0.0168802f
Cext_4776 PB.$5748.li1 VDD.$505.met3 0.00436347f
Cext_4777 PB.$5750.li1 VDD.$314.li1 0.00107494f
Cext_4778 PB.$5750.li1 VDD.$332.li1 0.0166003f
Cext_4779 PB.$5752.li1 VDD.$316.li1 0.00107494f
Cext_4780 PB.$5752.li1 VDD.$333.li1 0.0164742f
Cext_4781 PB.$5754.li1 VDD.$318.li1 0.00107494f
Cext_4782 PB.$5754.li1 VDD.$334.li1 0.0172855f
Cext_4783 PB.$5756.li1 VDD.$320.li1 0.00107494f
Cext_4784 PB.$5756.li1 VDD.$335.li1 0.0166794f
Cext_4785 PB.$5758.li1 VDD.$322.li1 0.00107494f
Cext_4786 PB.$5758.li1 VDD.$336.li1 0.0168508f
Cext_4787 PB.$5760.li1 VDD.$324.li1 0.00107494f
Cext_4788 PB.$5760.li1 VDD.$337.li1 0.0166794f
Cext_4789 PB.$5762.li1 VDD.$326.li1 0.00103015f
Cext_4790 PB.$5762.li1 VDD.$338.li1 0.0158673f
Cext_4791 PB.$5762.li1 VDD.$761.nwell 0.00238369f
Cext_4792 PB.$5762.li1 sky130_gnd 0.00440788f
Cext_4793 PB.$5764.met1 VDD.$500.met3 0.00123003f
Cext_4794 PB.$5764.met1 VDD.$662.nwell 0.00306058f
Cext_4795 PB.$5764.met1 sky130_gnd 0.0171206f
Cext_4796 PB.$5765.met1 VDD.$683.nwell 0.00306058f
Cext_4797 PB.$5765.met1 sky130_gnd 0.0190033f
Cext_4798 PB.$5766.met1 VDD.$500.met3 0.00105693f
Cext_4799 PB.$5766.met1 VDD.$662.nwell 0.0010666f
Cext_4800 PB.$5766.met1 sky130_gnd 0.0111713f
Cext_4801 PB.$5767.met1 VDD.$683.nwell 0.0010666f
Cext_4802 PB.$5767.met1 sky130_gnd 0.0132568f
Cext_4803 PB.$5768.met1 VDD.$662.nwell 0.0010666f
Cext_4804 PB.$5768.met1 sky130_gnd 0.0111713f
Cext_4805 PB.$5769.met1 VDD.$683.nwell 0.0010666f
Cext_4806 PB.$5769.met1 sky130_gnd 0.0132568f
Cext_4807 PB.$5770.met1 VDD.$500.met3 0.00108817f
Cext_4808 PB.$5770.met1 VDD.$662.nwell 0.0010666f
Cext_4809 PB.$5770.met1 sky130_gnd 0.0111713f
Cext_4810 PB.$5771.met1 VDD.$683.nwell 0.0010666f
Cext_4811 PB.$5771.met1 sky130_gnd 0.0132568f
Cext_4812 PB.$5772.met1 VDD.$500.met3 0.00100695f
Cext_4813 PB.$5772.met1 VDD.$662.nwell 0.0010666f
Cext_4814 PB.$5772.met1 sky130_gnd 0.0111713f
Cext_4815 PB.$5773.met1 VDD.$683.nwell 0.0010666f
Cext_4816 PB.$5773.met1 sky130_gnd 0.0132568f
Cext_4817 PB.$5774.met1 VDD.$662.nwell 0.0010666f
Cext_4818 PB.$5774.met1 sky130_gnd 0.0111713f
Cext_4819 PB.$5775.met1 VDD.$683.nwell 0.0010666f
Cext_4820 PB.$5775.met1 sky130_gnd 0.0132568f
Cext_4821 PB.$5776.met1 VDD.$500.met3 0.00111629f
Cext_4822 PB.$5776.met1 VDD.$662.nwell 0.0010666f
Cext_4823 PB.$5776.met1 sky130_gnd 0.0111713f
Cext_4824 PB.$5777.met1 VDD.$683.nwell 0.0010666f
Cext_4825 PB.$5777.met1 sky130_gnd 0.0132568f
Cext_4826 PB.$5778.met1 VDD.$662.nwell 0.0010666f
Cext_4827 PB.$5778.met1 sky130_gnd 0.0111713f
Cext_4828 PB.$5779.met1 VDD.$683.nwell 0.0010666f
Cext_4829 PB.$5779.met1 sky130_gnd 0.0132568f
Cext_4830 PB.$5780.met1 VDD.$662.nwell 0.0010666f
Cext_4831 PB.$5780.met1 sky130_gnd 0.0111713f
Cext_4832 PB.$5781.met1 VDD.$683.nwell 0.0010666f
Cext_4833 PB.$5781.met1 sky130_gnd 0.0132568f
Cext_4834 PB.$5782.met1 VDD.$683.nwell 0.00164885f
Cext_4835 PB.$5782.met1 sky130_gnd 0.00217521f
Cext_4836 PB.$5783.met1 VDD.$662.nwell 0.0010666f
Cext_4837 PB.$5783.met1 sky130_gnd 0.0111713f
Cext_4838 PB.$5784.met1 VDD.$683.nwell 0.0010666f
Cext_4839 PB.$5784.met1 sky130_gnd 0.0132568f
Cext_4840 PB.$5785.met1 VDD.$662.nwell 0.00449626f
Cext_4841 PB.$5785.met1 sky130_gnd 0.0138051f
Cext_4842 PB.$5786.met1 VDD.$683.nwell 0.0046444f
Cext_4843 PB.$5786.met1 sky130_gnd 0.0155255f
Cext_4844 PB.$5787.met1 VDD.$662.nwell 0.0040557f
Cext_4845 PB.$5787.met1 sky130_gnd 0.0143749f
Cext_4846 PB.$5788.met1 VDD.$683.nwell 0.0040557f
Cext_4847 PB.$5788.met1 sky130_gnd 0.0162576f
Cext_4848 PB.$5789.met1 VDD.$501.met3 0.0010132f
Cext_4849 PB.$5789.met1 sky130_gnd 0.0111713f
Cext_4850 PB.$5790.met1 VDD.$683.nwell 0.00157969f
Cext_4851 PB.$5790.met1 sky130_gnd 0.0134048f
Cext_4852 PB.$5791.met1 sky130_gnd 0.00288055f
Cext_4853 PB.$5792.met1 VDD.$501.met3 0.00108193f
Cext_4854 PB.$5792.met1 VDD.$684.nwell 0.0010666f
Cext_4855 PB.$5792.met1 sky130_gnd 0.0111713f
Cext_4856 PB.$5793.met1 VDD.$705.nwell 0.00131195f
Cext_4857 PB.$5793.met1 sky130_gnd 0.0122291f
Cext_4858 PB.$5794.met1 VDD.$684.nwell 0.0010666f
Cext_4859 PB.$5794.met1 sky130_gnd 0.0111713f
Cext_4860 PB.$5795.met1 VDD.$705.nwell 0.0010666f
Cext_4861 PB.$5795.met1 sky130_gnd 0.0132568f
Cext_4862 PB.$5796.met1 VDD.$501.met3 0.00106318f
Cext_4863 PB.$5796.met1 VDD.$684.nwell 0.0010666f
Cext_4864 PB.$5796.met1 sky130_gnd 0.0111713f
Cext_4865 PB.$5797.met1 VDD.$705.nwell 0.0010666f
Cext_4866 PB.$5797.met1 sky130_gnd 0.0132568f
Cext_4867 PB.$5798.met1 VDD.$501.met3 0.00103194f
Cext_4868 PB.$5798.met1 VDD.$684.nwell 0.0010666f
Cext_4869 PB.$5798.met1 sky130_gnd 0.0111713f
Cext_4870 PB.$5799.met1 VDD.$705.nwell 0.0010666f
Cext_4871 PB.$5799.met1 sky130_gnd 0.0132568f
Cext_4872 PB.$5800.met1 VDD.$684.nwell 0.0010666f
Cext_4873 PB.$5800.met1 sky130_gnd 0.0111713f
Cext_4874 PB.$5801.met1 VDD.$705.nwell 0.0010666f
Cext_4875 PB.$5801.met1 sky130_gnd 0.0132568f
Cext_4876 PB.$5802.met1 VDD.$501.met3 0.00111317f
Cext_4877 PB.$5802.met1 VDD.$684.nwell 0.0010666f
Cext_4878 PB.$5802.met1 sky130_gnd 0.0111713f
Cext_4879 PB.$5803.met1 VDD.$705.nwell 0.0010666f
Cext_4880 PB.$5803.met1 sky130_gnd 0.0132568f
Cext_4881 PB.$5804.met1 VDD.$684.nwell 0.0010666f
Cext_4882 PB.$5804.met1 sky130_gnd 0.0111713f
Cext_4883 PB.$5805.met1 VDD.$705.nwell 0.0010666f
Cext_4884 PB.$5805.met1 sky130_gnd 0.0132568f
Cext_4885 PB.$5806.met1 sky130_gnd 0.0113012f
Cext_4886 PB.$5807.met1 VDD.$705.nwell 0.0010666f
Cext_4887 PB.$5807.met1 sky130_gnd 0.0132568f
Cext_4888 PB.$5808.met1 TAIL.$265.met1 0.00141215f
Cext_4889 PB.$5808.met1 TAIL.$340.met3 0.00350529f
Cext_4890 PB.$5808.met1 VSS.$14.li1 0.00493987f
Cext_4891 PB.$5808.met1 VSS.$236.met1 0.00202003f
Cext_4892 PB.$5808.met1 sky130_gnd 0.0149001f
Cext_4893 PB.$5809.met1 TAIL.$309.met1 0.00149642f
Cext_4894 PB.$5809.met1 TAIL.$340.met3 0.00912325f
Cext_4895 PB.$5809.met1 sky130_gnd 0.00161828f
Cext_4896 PB.$5810.met1 TAIL.$267.met1 0.00183333f
Cext_4897 PB.$5810.met1 TAIL.$340.met3 0.00324916f
Cext_4898 PB.$5810.met1 VSS.$18.li1 0.00622939f
Cext_4899 PB.$5810.met1 VSS.$238.met1 0.00262252f
Cext_4900 PB.$5810.met1 sky130_gnd 0.00776772f
Cext_4901 PB.$5811.met1 TAIL.$268.met1 0.00183333f
Cext_4902 PB.$5811.met1 VSS.$20.li1 0.00618631f
Cext_4903 PB.$5811.met1 VSS.$239.met1 0.00233113f
Cext_4904 PB.$5811.met1 sky130_gnd 0.00776772f
Cext_4905 PB.$5812.met1 TAIL.$269.met1 0.00184549f
Cext_4906 PB.$5812.met1 VSS.$22.li1 0.00619788f
Cext_4907 PB.$5812.met1 VSS.$240.met1 0.00233113f
Cext_4908 PB.$5812.met1 sky130_gnd 0.00776772f
Cext_4909 PB.$5813.met1 TAIL.$270.met1 0.00189586f
Cext_4910 PB.$5813.met1 VSS.$24.li1 0.00655831f
Cext_4911 PB.$5813.met1 VSS.$241.met1 0.00233113f
Cext_4912 PB.$5813.met1 sky130_gnd 0.00776772f
Cext_4913 PB.$5814.met1 TAIL.$271.met1 0.00189586f
Cext_4914 PB.$5814.met1 VSS.$242.met1 0.00470471f
Cext_4915 PB.$5814.met1 VSS.$26.li1 0.00402802f
Cext_4916 PB.$5814.met1 sky130_gnd 0.00776772f
Cext_4917 PB.$5815.met1 TAIL.$272.met1 0.00189586f
Cext_4918 PB.$5815.met1 VSS.$243.met1 0.00470471f
Cext_4919 PB.$5815.met1 VSS.$28.li1 0.00402802f
Cext_4920 PB.$5815.met1 sky130_gnd 0.00776772f
Cext_4921 PB.$5816.met1 TAIL.$273.met1 0.00189586f
Cext_4922 PB.$5816.met1 VSS.$244.met1 0.00470471f
Cext_4923 PB.$5816.met1 VSS.$30.li1 0.00402802f
Cext_4924 PB.$5816.met1 sky130_gnd 0.00776772f
Cext_4925 PB.$5817.met1 TAIL.$274.met1 0.00186807f
Cext_4926 PB.$5817.met1 VSS.$245.met1 0.00412906f
Cext_4927 PB.$5817.met1 VSS.$32.li1 0.00402802f
Cext_4928 PB.$5817.met1 VSS.$379.met2 0.00525433f
Cext_4929 PB.$5817.met1 sky130_gnd 0.00776772f
Cext_4930 PB.$5818.met1 TAIL.$275.met1 0.00188892f
Cext_4931 PB.$5818.met1 VSS.$246.met1 0.00353911f
Cext_4932 PB.$5818.met1 VSS.$34.li1 0.00504982f
Cext_4933 PB.$5818.met1 VSS.$377.met2 0.0021408f
Cext_4934 PB.$5818.met1 VSS.$379.met2 0.00110674f
Cext_4935 PB.$5818.met1 sky130_gnd 0.00776772f
Cext_4936 PB.$5819.met1 TAIL.$276.met1 0.00189586f
Cext_4937 PB.$5819.met1 VSS.$247.met1 0.00376385f
Cext_4938 PB.$5819.met1 VSS.$36.li1 0.00430895f
Cext_4939 PB.$5819.met1 VSS.$377.met2 0.00282922f
Cext_4940 PB.$5819.met1 sky130_gnd 0.00776772f
Cext_4941 PB.$5820.met1 TAIL.$277.met1 0.00189586f
Cext_4942 PB.$5820.met1 VSS.$248.met1 0.00464519f
Cext_4943 PB.$5820.met1 VSS.$377.met2 0.00289214f
Cext_4944 PB.$5820.met1 VSS.$38.li1 0.00402802f
Cext_4945 PB.$5820.met1 VSS.$417.met3 0.0129163f
Cext_4946 PB.$5820.met1 sky130_gnd 0.00776772f
Cext_4947 PB.$5821.met1 TAIL.$278.met1 0.00189586f
Cext_4948 PB.$5821.met1 VSS.$249.met1 0.00369661f
Cext_4949 PB.$5821.met1 VSS.$377.met2 0.00344087f
Cext_4950 PB.$5821.met1 VSS.$40.li1 0.00447912f
Cext_4951 PB.$5821.met1 sky130_gnd 0.00776772f
Cext_4952 PB.$5822.met1 TAIL.$279.met1 0.00189586f
Cext_4953 PB.$5822.met1 VSS.$250.met1 0.00244142f
Cext_4954 PB.$5822.met1 VSS.$377.met2 0.00515542f
Cext_4955 PB.$5822.met1 VSS.$42.li1 0.00376391f
Cext_4956 PB.$5822.met1 sky130_gnd 0.00776772f
Cext_4957 PB.$5823.met1 TAIL.$280.met1 0.00189586f
Cext_4958 PB.$5823.met1 VSS.$13.li1 0.00453152f
Cext_4959 PB.$5823.met1 VSS.$251.met1 0.00233113f
Cext_4960 PB.$5823.met1 VSS.$377.met2 0.00526572f
Cext_4961 PB.$5823.met1 sky130_gnd 0.00776772f
Cext_4962 PB.$5824.met1 TAIL.$281.met1 0.00189586f
Cext_4963 PB.$5824.met1 VSS.$13.li1 0.00453152f
Cext_4964 PB.$5824.met1 VSS.$252.met1 0.00233113f
Cext_4965 PB.$5824.met1 VSS.$377.met2 0.00526572f
Cext_4966 PB.$5824.met1 sky130_gnd 0.00776772f
Cext_4967 PB.$5825.met1 TAIL.$282.met1 0.00189586f
Cext_4968 PB.$5825.met1 VSS.$13.li1 0.00453152f
Cext_4969 PB.$5825.met1 VSS.$253.met1 0.00233113f
Cext_4970 PB.$5825.met1 VSS.$377.met2 0.00526572f
Cext_4971 PB.$5825.met1 sky130_gnd 0.00776772f
Cext_4972 PB.$5826.met1 TAIL.$283.met1 0.00189586f
Cext_4973 PB.$5826.met1 VSS.$13.li1 0.00453152f
Cext_4974 PB.$5826.met1 VSS.$254.met1 0.00233113f
Cext_4975 PB.$5826.met1 VSS.$377.met2 0.00526572f
Cext_4976 PB.$5826.met1 sky130_gnd 0.00776772f
Cext_4977 PB.$5827.met1 TAIL.$284.met1 0.00189586f
Cext_4978 PB.$5827.met1 VSS.$13.li1 0.00453152f
Cext_4979 PB.$5827.met1 VSS.$255.met1 0.00233113f
Cext_4980 PB.$5827.met1 VSS.$377.met2 0.00526572f
Cext_4981 PB.$5827.met1 sky130_gnd 0.00776772f
Cext_4982 PB.$5828.met1 TAIL.$285.met1 0.00183854f
Cext_4983 PB.$5828.met1 VSS.$13.li1 0.00542305f
Cext_4984 PB.$5828.met1 VSS.$256.met1 0.00233113f
Cext_4985 PB.$5828.met1 VSS.$377.met2 0.00560389f
Cext_4986 PB.$5828.met1 VSS.$417.met3 0.012328f
Cext_4987 PB.$5828.met1 sky130_gnd 0.00776772f
Cext_4988 PB.$5829.met1 TAIL.$286.met1 0.00183333f
Cext_4989 PB.$5829.met1 VSS.$13.li1 0.00745148f
Cext_4990 PB.$5829.met1 VSS.$234.met1 0.00395506f
Cext_4991 PB.$5829.met1 VSS.$257.met1 0.00145695f
Cext_4992 PB.$5829.met1 VSS.$376.met2 0.0024624f
Cext_4993 PB.$5829.met1 VSS.$377.met2 0.00113943f
Cext_4994 PB.$5829.met1 VSS.$417.met3 0.00561286f
Cext_4995 PB.$5829.met1 sky130_gnd 0.0043154f
Cext_4996 PB.$5830.met1 TAIL.$287.met1 0.00185004f
Cext_4997 PB.$5830.met1 VSS.$13.li1 0.00756241f
Cext_4998 PB.$5830.met1 VSS.$234.met1 0.00395506f
Cext_4999 PB.$5830.met1 VSS.$376.met2 0.00154652f
Cext_5000 PB.$5830.met1 sky130_gnd 0.0046088f
Cext_5001 PB.$5831.met1 TAIL.$288.met1 0.00189076f
Cext_5002 PB.$5831.met1 VSS.$13.li1 0.00638564f
Cext_5003 PB.$5831.met1 sky130_gnd 0.0102091f
Cext_5004 PB.$5832.met1 TAIL.$289.met1 0.0019085f
Cext_5005 PB.$5832.met1 VSS.$13.li1 0.0065542f
Cext_5006 PB.$5832.met1 sky130_gnd 0.0119209f
Cext_5007 PB.$5833.met1 TAIL.$290.met1 0.0019085f
Cext_5008 PB.$5833.met1 VSS.$13.li1 0.0065542f
Cext_5009 PB.$5833.met1 sky130_gnd 0.0119209f
Cext_5010 PB.$5834.met1 TAIL.$291.met1 0.0019085f
Cext_5011 PB.$5834.met1 VSS.$13.li1 0.0065542f
Cext_5012 PB.$5834.met1 sky130_gnd 0.0119209f
Cext_5013 PB.$5835.met1 TAIL.$292.met1 0.0019085f
Cext_5014 PB.$5835.met1 VSS.$13.li1 0.0065542f
Cext_5015 PB.$5835.met1 sky130_gnd 0.0119209f
Cext_5016 PB.$5836.met1 TAIL.$293.met1 0.0019085f
Cext_5017 PB.$5836.met1 VSS.$13.li1 0.0065542f
Cext_5018 PB.$5836.met1 sky130_gnd 0.0119209f
Cext_5019 PB.$5837.met1 TAIL.$294.met1 0.0019085f
Cext_5020 PB.$5837.met1 VSS.$13.li1 0.0065542f
Cext_5021 PB.$5837.met1 sky130_gnd 0.0119209f
Cext_5022 PB.$5838.met1 TAIL.$295.met1 0.0019085f
Cext_5023 PB.$5838.met1 VSS.$13.li1 0.0065542f
Cext_5024 PB.$5838.met1 sky130_gnd 0.0119209f
Cext_5025 PB.$5839.met1 TAIL.$296.met1 0.0019085f
Cext_5026 PB.$5839.met1 VSS.$13.li1 0.0065542f
Cext_5027 PB.$5839.met1 sky130_gnd 0.0119209f
Cext_5028 PB.$5840.met1 TAIL.$297.met1 0.0019085f
Cext_5029 PB.$5840.met1 VSS.$13.li1 0.0065542f
Cext_5030 PB.$5840.met1 VSS.$417.met3 0.0126067f
Cext_5031 PB.$5840.met1 sky130_gnd 0.0119209f
Cext_5032 PB.$5841.met1 TAIL.$298.met1 0.0019085f
Cext_5033 PB.$5841.met1 VSS.$13.li1 0.0065542f
Cext_5034 PB.$5841.met1 sky130_gnd 0.0119209f
Cext_5035 PB.$5842.met1 TAIL.$299.met1 0.0019085f
Cext_5036 PB.$5842.met1 VSS.$13.li1 0.0065542f
Cext_5037 PB.$5842.met1 sky130_gnd 0.0119209f
Cext_5038 PB.$5843.met1 TAIL.$300.met1 0.0019085f
Cext_5039 PB.$5843.met1 VSS.$13.li1 0.0065542f
Cext_5040 PB.$5843.met1 sky130_gnd 0.0119209f
Cext_5041 PB.$5844.met1 TAIL.$301.met1 0.0019085f
Cext_5042 PB.$5844.met1 VSS.$13.li1 0.0065542f
Cext_5043 PB.$5844.met1 sky130_gnd 0.0119209f
Cext_5044 PB.$5845.met1 TAIL.$302.met1 0.0019085f
Cext_5045 PB.$5845.met1 VSS.$13.li1 0.0065542f
Cext_5046 PB.$5845.met1 sky130_gnd 0.0119209f
Cext_5047 PB.$5846.met1 TAIL.$303.met1 0.0019085f
Cext_5048 PB.$5846.met1 VSS.$13.li1 0.0065542f
Cext_5049 PB.$5846.met1 sky130_gnd 0.0119209f
Cext_5050 PB.$5847.met1 TAIL.$304.met1 0.0019085f
Cext_5051 PB.$5847.met1 VSS.$13.li1 0.0065542f
Cext_5052 PB.$5847.met1 sky130_gnd 0.0119209f
Cext_5053 PB.$5848.met1 TAIL.$305.met1 0.0019085f
Cext_5054 PB.$5848.met1 VSS.$13.li1 0.0065542f
Cext_5055 PB.$5848.met1 sky130_gnd 0.0119209f
Cext_5056 PB.$5849.met1 TAIL.$306.met1 0.0019085f
Cext_5057 PB.$5849.met1 VSS.$13.li1 0.0065542f
Cext_5058 PB.$5849.met1 sky130_gnd 0.0119209f
Cext_5059 PB.$5850.met1 TAIL.$307.met1 0.0019085f
Cext_5060 PB.$5850.met1 VSS.$13.li1 0.0065542f
Cext_5061 PB.$5850.met1 sky130_gnd 0.0119209f
Cext_5062 PB.$5851.met1 TAIL.$308.met1 0.00172295f
Cext_5063 PB.$5851.met1 VSS.$13.li1 0.00591698f
Cext_5064 PB.$5851.met1 sky130_gnd 0.0185799f
Cext_5065 PB.$5852.met1 TAIL.$340.met3 0.00645053f
Cext_5066 PB.$5852.met1 VSS.$16.li1 0.00923032f
Cext_5067 PB.$5852.met1 VSS.$237.met1 0.00272738f
Cext_5068 PB.$5852.met1 VSS.$249.met1 0.00409463f
Cext_5069 PB.$5852.met1 sky130_gnd 0.0120364f
Cext_5070 PB.$5853.met1 VDD.$684.nwell 0.00455551f
Cext_5071 PB.$5853.met1 sky130_gnd 0.0140649f
Cext_5072 PB.$5854.met1 VDD.$705.nwell 0.0046444f
Cext_5073 PB.$5854.met1 sky130_gnd 0.0155255f
Cext_5074 PB.$5855.met1 sky130_gnd 0.00208321f
Cext_5075 PB.$5856.met1 VDD.$416.met1 0.00143089f
Cext_5076 PB.$5856.met1 VDD.$482.met2 0.00375118f
Cext_5077 PB.$5856.met1 VDD.$483.met2 0.00699511f
Cext_5078 PB.$5856.met1 VDD.$502.met3 0.00104099f
Cext_5079 PB.$5856.met1 VDD.$684.nwell 0.0040557f
Cext_5080 PB.$5856.met1 sky130_gnd 0.0162576f
Cext_5081 PB.$5857.met1 VDD.$705.nwell 0.00272995f
Cext_5082 PB.$5857.met1 sky130_gnd 0.0132968f
Cext_5083 PB.$5858.met1 VDD.$705.nwell 0.00243212f
Cext_5084 PB.$5858.met1 sky130_gnd 0.00375518f
Cext_5085 PB.$5859.met1 VDD.$502.met3 0.00200651f
Cext_5086 PB.$5859.met1 sky130_gnd 0.0132568f
Cext_5087 PB.$5860.met1 sky130_gnd 0.0131989f
Cext_5088 PB.$5861.met1 VDD.$502.met3 0.00211903f
Cext_5089 PB.$5861.met1 VDD.$706.nwell 0.0010666f
Cext_5090 PB.$5861.met1 sky130_gnd 0.0132568f
Cext_5091 PB.$5862.met1 VDD.$727.nwell 0.0010666f
Cext_5092 PB.$5862.met1 sky130_gnd 0.0132568f
Cext_5093 PB.$5863.met1 VDD.$502.met3 0.00225838f
Cext_5094 PB.$5863.met1 VDD.$706.nwell 0.0010666f
Cext_5095 PB.$5863.met1 sky130_gnd 0.0132568f
Cext_5096 PB.$5864.met1 VDD.$727.nwell 0.0010666f
Cext_5097 PB.$5864.met1 sky130_gnd 0.0132568f
Cext_5098 PB.$5865.met1 VDD.$502.met3 0.00200535f
Cext_5099 PB.$5865.met1 VDD.$706.nwell 0.0010666f
Cext_5100 PB.$5865.met1 sky130_gnd 0.0132568f
Cext_5101 PB.$5866.met1 VDD.$727.nwell 0.0010666f
Cext_5102 PB.$5866.met1 sky130_gnd 0.0132568f
Cext_5103 PB.$5867.met1 VDD.$502.met3 0.00217771f
Cext_5104 PB.$5867.met1 VDD.$706.nwell 0.0010666f
Cext_5105 PB.$5867.met1 VREF.$101.met2 0.0135908f
Cext_5106 PB.$5867.met1 sky130_gnd 0.0132568f
Cext_5107 PB.$5868.met1 VDD.$727.nwell 0.0010666f
Cext_5108 PB.$5868.met1 sky130_gnd 0.0132568f
Cext_5109 PB.$5869.met1 VDD.$502.met3 0.00219971f
Cext_5110 PB.$5869.met1 VDD.$706.nwell 0.0010666f
Cext_5111 PB.$5869.met1 sky130_gnd 0.0132568f
Cext_5112 PB.$5870.met1 VDD.$727.nwell 0.0010666f
Cext_5113 PB.$5870.met1 sky130_gnd 0.0132568f
Cext_5114 PB.$5871.met1 VDD.$502.met3 0.00200535f
Cext_5115 PB.$5871.met1 VDD.$706.nwell 0.0010666f
Cext_5116 PB.$5871.met1 sky130_gnd 0.0132568f
Cext_5117 PB.$5872.met1 VDD.$727.nwell 0.0010666f
Cext_5118 PB.$5872.met1 sky130_gnd 0.0132568f
Cext_5119 PB.$5873.met1 VDD.$502.met3 0.00223638f
Cext_5120 PB.$5873.met1 VDD.$706.nwell 0.0010666f
Cext_5121 PB.$5873.met1 sky130_gnd 0.0132568f
Cext_5122 PB.$5874.met1 VDD.$727.nwell 0.0010666f
Cext_5123 PB.$5874.met1 sky130_gnd 0.0132568f
Cext_5124 PB.$5875.met1 VDD.$502.met3 0.00214104f
Cext_5125 PB.$5875.met1 VDD.$706.nwell 0.0010666f
Cext_5126 PB.$5875.met1 sky130_gnd 0.0132568f
Cext_5127 PB.$5876.met1 VDD.$727.nwell 0.0010666f
Cext_5128 PB.$5876.met1 sky130_gnd 0.0132568f
Cext_5129 PB.$5877.met1 VDD.$503.met3 0.00139261f
Cext_5130 PB.$5877.met1 VDD.$706.nwell 0.0046444f
Cext_5131 PB.$5877.met1 VREF.$101.met2 0.00541719f
Cext_5132 PB.$5877.met1 sky130_gnd 0.0155255f
Cext_5133 PB.$5878.met1 VDD.$727.nwell 0.0046444f
Cext_5134 PB.$5878.met1 sky130_gnd 0.0155255f
Cext_5135 PB.$5879.met1 VDD.$503.met3 0.00172395f
Cext_5136 PB.$5879.met1 VDD.$706.nwell 0.0040557f
Cext_5137 PB.$5879.met1 sky130_gnd 0.0162576f
Cext_5138 PB.$5880.met1 VDD.$727.nwell 0.0038347f
Cext_5139 PB.$5880.met1 sky130_gnd 0.0162576f
Cext_5140 PB.$5881.met1 sky130_gnd 0.0132568f
Cext_5141 PB.$5882.met1 VDD.$727.nwell 0.00108392f
Cext_5142 PB.$5882.met1 sky130_gnd 0.0134531f
Cext_5143 PB.$5883.met1 VDD.$727.nwell 0.00115495f
Cext_5144 PB.$5883.met1 sky130_gnd 0.00214832f
Cext_5145 PB.$5884.met1 VDD.$728.nwell 0.0010666f
Cext_5146 PB.$5884.met1 sky130_gnd 0.0132568f
Cext_5147 PB.$5885.met1 VDD.$749.nwell 0.0010666f
Cext_5148 PB.$5885.met1 sky130_gnd 0.0132568f
Cext_5149 PB.$5886.met1 VDD.$728.nwell 0.0010666f
Cext_5150 PB.$5886.met1 sky130_gnd 0.0132568f
Cext_5151 PB.$5887.met1 VDD.$749.nwell 0.0010666f
Cext_5152 PB.$5887.met1 sky130_gnd 0.0132568f
Cext_5153 PB.$5888.met1 VDD.$503.met3 0.00111629f
Cext_5154 PB.$5888.met1 VDD.$728.nwell 0.0010666f
Cext_5155 PB.$5888.met1 sky130_gnd 0.0132568f
Cext_5156 PB.$5889.met1 VDD.$749.nwell 0.0010666f
Cext_5157 PB.$5889.met1 sky130_gnd 0.0132568f
Cext_5158 PB.$5890.met1 VDD.$728.nwell 0.0010666f
Cext_5159 PB.$5890.met1 sky130_gnd 0.0132568f
Cext_5160 PB.$5891.met1 VDD.$749.nwell 0.0010666f
Cext_5161 PB.$5891.met1 sky130_gnd 0.0132568f
Cext_5162 PB.$5892.met1 VDD.$503.met3 0.0010132f
Cext_5163 PB.$5892.met1 VDD.$728.nwell 0.0010666f
Cext_5164 PB.$5892.met1 sky130_gnd 0.0132568f
Cext_5165 PB.$5893.met1 VDD.$749.nwell 0.0010666f
Cext_5166 PB.$5893.met1 sky130_gnd 0.0132568f
Cext_5167 PB.$5894.met1 VDD.$503.met3 0.00108193f
Cext_5168 PB.$5894.met1 VDD.$728.nwell 0.0010666f
Cext_5169 PB.$5894.met1 sky130_gnd 0.0132568f
Cext_5170 PB.$5895.met1 VDD.$749.nwell 0.0010666f
Cext_5171 PB.$5895.met1 sky130_gnd 0.0132568f
Cext_5172 PB.$5896.met1 VDD.$728.nwell 0.0010666f
Cext_5173 PB.$5896.met1 sky130_gnd 0.0132568f
Cext_5174 PB.$5897.met1 VDD.$749.nwell 0.0010666f
Cext_5175 PB.$5897.met1 sky130_gnd 0.0132568f
Cext_5176 PB.$5898.met1 VDD.$728.nwell 0.0010666f
Cext_5177 PB.$5898.met1 sky130_gnd 0.0132568f
Cext_5178 PB.$5899.met1 VDD.$749.nwell 0.0010666f
Cext_5179 PB.$5899.met1 sky130_gnd 0.0132568f
Cext_5180 PB.$5900.met1 VDD.$728.nwell 0.0046444f
Cext_5181 PB.$5900.met1 sky130_gnd 0.0155255f
Cext_5182 PB.$5901.met1 VDD.$749.nwell 0.00423802f
Cext_5183 PB.$5901.met1 sky130_gnd 0.0178259f
Cext_5184 PB.$5902.met1 S.$14.li1 0.00165428f
Cext_5185 PB.$5902.met1 S.$26.met1 0.00297871f
Cext_5186 PB.$5902.met1 S.$27.met1 0.0054382f
Cext_5187 PB.$5902.met1 S.$39.poly 0.00100725f
Cext_5188 PB.$5902.met1 S.$40.poly 0.00140544f
Cext_5189 PB.$5902.met1 S.P0.poly 0.00785956f
Cext_5190 PB.$5902.met1 VSS.$308.met1 0.00704157f
Cext_5191 PB.$5902.met1 sky130_gnd 0.012553f
Cext_5192 PB.$5903.met1 S.P0.poly 0.00217444f
Cext_5193 PB.$5903.met1 VSS.$119.li1 0.00862215f
Cext_5194 PB.$5903.met1 VSS.$307.met1 0.00157143f
Cext_5195 PB.$5903.met1 VSS.$309.met1 0.00776967f
Cext_5196 PB.$5903.met1 sky130_gnd 0.0144967f
Cext_5197 PB.$5904.met1 VDD.$328.li1 0.00132723f
Cext_5198 PB.$5904.met1 VDD.$459.met1 0.00165509f
Cext_5199 PB.$5904.met1 VDD.$761.nwell 0.00398189f
Cext_5200 PB.$5904.met1 sky130_gnd 0.00997137f
Cext_5201 PB.$5905.met1 VDD.$329.li1 0.0042627f
Cext_5202 PB.$5905.met1 VDD.$460.met1 0.00183333f
Cext_5203 PB.$5905.met1 VDD.$494.met2 0.00149701f
Cext_5204 PB.$5905.met1 VDD.$761.nwell 0.00154063f
Cext_5205 PB.$5905.met1 VSS.$489.poly 0.00150306f
Cext_5206 PB.$5905.met1 sky130_gnd 0.00501858f
Cext_5207 PB.$5906.met1 VDD.$330.li1 0.0061904f
Cext_5208 PB.$5906.met1 VDD.$461.met1 0.00183333f
Cext_5209 PB.$5906.met1 VDD.$494.met2 0.00234566f
Cext_5210 PB.$5906.met1 VDD.$506.met3 0.0042764f
Cext_5211 PB.$5906.met1 VDD.$761.nwell 0.002079f
Cext_5212 PB.$5906.met1 VDD.P0.nwell 0.00173444f
Cext_5213 PB.$5906.met1 sky130_gnd 0.00649879f
Cext_5214 PB.$5907.met1 VDD.$331.li1 0.00621506f
Cext_5215 PB.$5907.met1 VDD.$462.met1 0.00183333f
Cext_5216 PB.$5907.met1 VDD.$494.met2 0.00234566f
Cext_5217 PB.$5907.met1 VDD.$505.met3 0.00894445f
Cext_5218 PB.$5907.met1 VDD.$506.met3 0.00691367f
Cext_5219 PB.$5907.met1 VDD.$761.nwell 0.00158074f
Cext_5220 PB.$5907.met1 sky130_gnd 0.0101989f
Cext_5221 PB.$5908.met1 VDD.$332.li1 0.00620724f
Cext_5222 PB.$5908.met1 VDD.$463.met1 0.00183333f
Cext_5223 PB.$5908.met1 VDD.$493.met2 0.00101249f
Cext_5224 PB.$5908.met1 VDD.$494.met2 0.00152261f
Cext_5225 PB.$5908.met1 VDD.$505.met3 0.0010882f
Cext_5226 PB.$5908.met1 VDD.$506.met3 0.00178517f
Cext_5227 PB.$5908.met1 VDD.$761.nwell 0.00158074f
Cext_5228 PB.$5908.met1 sky130_gnd 0.0106614f
Cext_5229 PB.$5909.met1 VDD.$333.li1 0.0091061f
Cext_5230 PB.$5909.met1 VDD.$464.met1 0.00183333f
Cext_5231 PB.$5909.met1 VDD.$470.met1 0.00834062f
Cext_5232 PB.$5909.met1 VDD.$493.met2 0.00274842f
Cext_5233 PB.$5909.met1 sky130_gnd 0.0011846f
Cext_5234 PB.$5910.met1 VDD.$334.li1 0.00639655f
Cext_5235 PB.$5910.met1 VDD.$465.met1 0.00183333f
Cext_5236 PB.$5910.met1 VDD.$493.met2 0.00550332f
Cext_5237 PB.$5910.met1 VDD.$761.nwell 0.00158074f
Cext_5238 PB.$5910.met1 sky130_gnd 0.0106614f
Cext_5239 PB.$5911.met1 VDD.$335.li1 0.00639308f
Cext_5240 PB.$5911.met1 VDD.$466.met1 0.00183333f
Cext_5241 PB.$5911.met1 VDD.$506.met3 0.00937409f
Cext_5242 PB.$5911.met1 VDD.$761.nwell 0.00158074f
Cext_5243 PB.$5911.met1 sky130_gnd 0.0106614f
Cext_5244 PB.$5912.met1 VDD.$336.li1 0.00642435f
Cext_5245 PB.$5912.met1 VDD.$467.met1 0.00183333f
Cext_5246 PB.$5912.met1 VDD.$761.nwell 0.00158074f
Cext_5247 PB.$5912.met1 sky130_gnd 0.0106614f
Cext_5248 PB.$5913.met1 VDD.$337.li1 0.00642435f
Cext_5249 PB.$5913.met1 VDD.$468.met1 0.00183333f
Cext_5250 PB.$5913.met1 VDD.$761.nwell 0.00158074f
Cext_5251 PB.$5913.met1 sky130_gnd 0.0106614f
Cext_5252 PB.$5914.met1 VDD.$338.li1 0.00579976f
Cext_5253 PB.$5914.met1 VDD.$469.met1 0.00165509f
Cext_5254 PB.$5914.met1 VDD.$761.nwell 0.00388979f
Cext_5255 PB.$5914.met1 sky130_gnd 0.0162952f
Cext_5256 PB.$5915.met1 VDD.$328.li1 0.00685427f
Cext_5257 PB.$5915.met1 VDD.$329.li1 0.00235404f
Cext_5258 PB.$5915.met1 VDD.$334.li1 0.00346113f
Cext_5259 PB.$5915.met1 VDD.$472.met1 0.00199217f
Cext_5260 PB.$5915.met1 VDD.$495.met2 0.00285885f
Cext_5261 PB.$5915.met1 VDD.$761.nwell 0.00252593f
Cext_5262 PB.$5915.met1 sky130_gnd 0.00867954f
Cext_5263 PB.$5916.met2 sky130_gnd 0.010969f
Cext_5264 PB.$5917.met2 VDD.$683.nwell 0.00498279f
Cext_5265 PB.$5917.met2 sky130_gnd 0.0123953f
Cext_5266 PB.$5918.met2 VDD.$683.nwell 0.00410013f
Cext_5267 PB.$5918.met2 sky130_gnd 0.0127227f
Cext_5268 PB.$5919.met2 VDD.$705.nwell 0.00223949f
Cext_5269 PB.$5919.met2 sky130_gnd 0.0093722f
Cext_5270 PB.$592.capm VDD.$508.met3 2.84182f
Cext_5271 PB.$592.capm VDD.P0.met3 21.2984f
Cext_5272 PB.$5920.met2 TAIL.$336.met2 0.00264014f
Cext_5273 PB.$5920.met2 TAIL.$340.met3 0.0524769f
Cext_5274 PB.$5920.met2 VSS.$14.li1 0.00372275f
Cext_5275 PB.$5920.met2 VSS.$16.li1 0.00274287f
Cext_5276 PB.$5920.met2 VSS.$249.met1 0.00564748f
Cext_5277 PB.$5920.met2 VSS.$379.met2 0.00354021f
Cext_5278 PB.$5920.met2 VSS.$380.met2 0.00452371f
Cext_5279 PB.$5920.met2 VSS.$40.li1 0.00161985f
Cext_5280 PB.$5920.met2 sky130_gnd 0.0627541f
Cext_5281 PB.$5921.met2 TAIL.$340.met3 0.0250382f
Cext_5282 PB.$5921.met2 VSS.$380.met2 0.00870117f
Cext_5283 PB.$5921.met2 sky130_gnd 0.144461f
Cext_5284 PB.$5922.met2 VDD.$481.met2 0.0013141f
Cext_5285 PB.$5922.met2 VDD.$705.nwell 0.0050159f
Cext_5286 PB.$5922.met2 sky130_gnd 0.0137931f
Cext_5287 PB.$5923.met2 VDD.$481.met2 0.00125f
Cext_5288 PB.$5923.met2 VDD.$727.nwell 0.00160887f
Cext_5289 PB.$5923.met2 sky130_gnd 0.00898273f
Cext_5290 PB.$5924.met2 VDD.$204.li1 0.00106154f
Cext_5291 PB.$5924.met2 VDD.$206.li1 0.00132227f
Cext_5292 PB.$5924.met2 VDD.$208.li1 0.0013409f
Cext_5293 PB.$5924.met2 VDD.$210.li1 0.0013409f
Cext_5294 PB.$5924.met2 VDD.$212.li1 0.0013409f
Cext_5295 PB.$5924.met2 VDD.$214.li1 0.0013409f
Cext_5296 PB.$5924.met2 VDD.$216.li1 0.0013409f
Cext_5297 PB.$5924.met2 VDD.$218.li1 0.0013409f
Cext_5298 PB.$5924.met2 VDD.$220.li1 0.0013409f
Cext_5299 PB.$5924.met2 VDD.$222.li1 0.0013409f
Cext_5300 PB.$5924.met2 VDD.$224.li1 0.00121053f
Cext_5301 PB.$5924.met2 VDD.$226.li1 0.00106154f
Cext_5302 PB.$5924.met2 VDD.$420.met1 0.00318939f
Cext_5303 PB.$5924.met2 VDD.$421.met1 0.00514433f
Cext_5304 PB.$5924.met2 VDD.$422.met1 0.00583625f
Cext_5305 PB.$5924.met2 VDD.$423.met1 0.00583625f
Cext_5306 PB.$5924.met2 VDD.$424.met1 0.00583625f
Cext_5307 PB.$5924.met2 VDD.$425.met1 0.00583625f
Cext_5308 PB.$5924.met2 VDD.$426.met1 0.00583625f
Cext_5309 PB.$5924.met2 VDD.$427.met1 0.00583625f
Cext_5310 PB.$5924.met2 VDD.$428.met1 0.00583625f
Cext_5311 PB.$5924.met2 VDD.$429.met1 0.00583625f
Cext_5312 PB.$5924.met2 VDD.$430.met1 0.00583625f
Cext_5313 PB.$5924.met2 VDD.$431.met1 0.00486355f
Cext_5314 PB.$5924.met2 VDD.$484.met2 0.018682f
Cext_5315 PB.$5924.met2 VDD.$485.met2 0.0822587f
Cext_5316 PB.$5924.met2 VDD.$486.met2 0.0216372f
Cext_5317 PB.$5924.met2 VDD.$487.met2 0.014101f
Cext_5318 PB.$5924.met2 VDD.$488.met2 0.00113332f
Cext_5319 PB.$5924.met2 VDD.$489.met2 0.00466394f
Cext_5320 PB.$5924.met2 VDD.$503.met3 0.0416827f
Cext_5321 PB.$5924.met2 VDD.$504.met3 0.0175907f
Cext_5322 PB.$5924.met2 VDD.P4.psdm 0.00168568f
Cext_5323 PB.$5925.met2 VDD.$228.li1 0.0012664f
Cext_5324 PB.$5925.met2 VDD.$230.li1 0.0013409f
Cext_5325 PB.$5925.met2 VDD.$232.li1 0.0013409f
Cext_5326 PB.$5925.met2 VDD.$234.li1 0.0013409f
Cext_5327 PB.$5925.met2 VDD.$236.li1 0.0013409f
Cext_5328 PB.$5925.met2 VDD.$238.li1 0.0013409f
Cext_5329 PB.$5925.met2 VDD.$240.li1 0.0013409f
Cext_5330 PB.$5925.met2 VDD.$242.li1 0.0013409f
Cext_5331 PB.$5925.met2 VDD.$244.li1 0.0013409f
Cext_5332 PB.$5925.met2 VDD.$246.li1 0.00121053f
Cext_5333 PB.$5925.met2 VDD.$432.met1 0.00624105f
Cext_5334 PB.$5925.met2 VDD.$433.met1 0.00649865f
Cext_5335 PB.$5925.met2 VDD.$434.met1 0.00649865f
Cext_5336 PB.$5925.met2 VDD.$435.met1 0.00649865f
Cext_5337 PB.$5925.met2 VDD.$436.met1 0.00649865f
Cext_5338 PB.$5925.met2 VDD.$437.met1 0.00649865f
Cext_5339 PB.$5925.met2 VDD.$438.met1 0.00649865f
Cext_5340 PB.$5925.met2 VDD.$439.met1 0.00649865f
Cext_5341 PB.$5925.met2 VDD.$440.met1 0.00649865f
Cext_5342 PB.$5925.met2 VDD.$441.met1 0.00586684f
Cext_5343 PB.$5925.met2 VDD.$484.met2 0.00555556f
Cext_5344 PB.$5925.met2 VDD.$503.met3 0.0190931f
Cext_5345 PB.$5925.met2 VDD.$727.nwell 0.00536161f
Cext_5346 PB.$5925.met2 VDD.P4.psdm 0.00321506f
Cext_5347 PB.$5925.met2 sky130_gnd 0.014532f
Cext_5348 PB.$5926.met2 VDD.$487.met2 0.00128361f
Cext_5349 PB.$5926.met2 VDD.$503.met3 0.0177113f
Cext_5350 PB.$5926.met2 VDD.$749.nwell 0.00215932f
Cext_5351 PB.$5926.met2 sky130_gnd 0.0111827f
Cext_5352 PB.$5927.met2 net1.$621.met3 0.133192f
Cext_5353 PB.$5927.met2 net2.$88.met2 0.0127844f
Cext_5354 PB.$5927.met2 net2.$91.met3 0.102492f
Cext_5355 PB.$5927.met2 VDD.$508.met3 0.017971f
Cext_5356 PB.$5927.met2 sky130_gnd 0.684949f
Cext_5357 PB.$5928.met2 S.$12.li1 0.00358954f
Cext_5358 PB.$5928.met2 S.$26.met1 0.00626475f
Cext_5359 PB.$5928.met2 S.$39.poly 0.00139631f
Cext_5360 PB.$5928.met2 VREF.$102.met2 0.00293939f
Cext_5361 PB.$5928.met2 VREF.$108.met3 0.0682378f
Cext_5362 PB.$5928.met2 sky130_gnd 0.770111f
Cext_5363 PB.$5929.met2 S.$25.met1 0.00395392f
Cext_5364 PB.$5929.met2 S.$27.met1 0.00809421f
Cext_5365 PB.$5929.met2 S.$40.poly 0.00233916f
Cext_5366 PB.$5929.met2 VSS.$405.met2 0.00867492f
Cext_5367 PB.$5929.met2 VSS.$409.met2 0.00966625f
Cext_5368 PB.$5929.met2 sky130_gnd 0.00647466f
Cext_5369 PB.$5930.met2 S 0.00224359f
Cext_5370 PB.$5930.met2 S.$12.li1 0.00137913f
Cext_5371 PB.$5930.met2 S.$24.met1 0.0107705f
Cext_5372 PB.$5930.met2 S.$26.met1 0.013749f
Cext_5373 PB.$5930.met2 S.$27.met1 0.00136813f
Cext_5374 PB.$5930.met2 S.$32.met2 0.0119102f
Cext_5375 PB.$5930.met2 S.$35.met3 0.0752212f
Cext_5376 PB.$5930.met2 S.$39.poly 0.0048053f
Cext_5377 PB.$5930.met2 S.P0.poly 0.00564859f
Cext_5378 PB.$5930.met2 VREF.$108.met3 0.015427f
Cext_5379 PB.$5930.met2 VSS.$119.li1 0.00370253f
Cext_5380 PB.$5930.met2 VSS.$405.met2 0.0100525f
Cext_5381 PB.$5930.met2 VSS.$409.met2 0.0122395f
Cext_5382 PB.$5930.met2 sky130_gnd 0.0647682f
Cext_5383 PB.$5931.met2 VDD.$492.met2 0.00230114f
Cext_5384 PB.$5931.met2 VDD.$506.met3 0.00241859f
Cext_5385 PB.$5931.met2 VDD.$750.nwell 0.00150423f
Cext_5386 PB.$5931.met2 VDD.$761.nwell 0.0039666f
Cext_5387 PB.$5931.met2 VDD.P2.nwell 0.00604144f
Cext_5388 PB.$5931.met2 sky130_gnd 0.117439f
Cext_5389 PB.$5932.met2 S.$35.met3 0.00364459f
Cext_5390 PB.$5932.met2 VSS.$408.met2 0.00498504f
Cext_5391 PB.$5932.met2 VSS.$409.met2 0.00371061f
Cext_5392 PB.$5932.met2 VSS.$410.met2 0.0557692f
Cext_5393 PB.$5932.met2 VSS.$428.met3 0.0178349f
Cext_5394 PB.$5932.met2 VSS.$429.met3 0.0868991f
Cext_5395 PB.$5932.met2 sky130_gnd 0.80129f
Cext_5396 PB.$5933.met2 VDD.$328.li1 0.00676688f
Cext_5397 PB.$5933.met2 VDD.$334.li1 0.00938959f
Cext_5398 PB.$5933.met2 VDD.$494.met2 0.0120762f
Cext_5399 PB.$5933.met2 VDD.$506.met3 0.00251413f
Cext_5400 PB.$5933.met2 VDD.$761.nwell 0.0121804f
Cext_5401 PB.$5933.met2 VSS.$410.met2 0.00390892f
Cext_5402 PB.$5933.met2 VSS.$411.met2 0.0601817f
Cext_5403 PB.$5933.met2 VSS.$489.poly 0.00403476f
Cext_5404 PB.$5933.met2 sky130_gnd 0.591538f
Cext_5405 PB.$5934.met3 VDD.$478.met2 0.00105401f
Cext_5406 PB.$5934.met3 VDD.$500.met3 0.00134058f
Cext_5407 PB.$5934.met3 VDD.$501.met3 0.0152817f
Cext_5408 PB.$5934.met3 VDD.$57.li1 0.0115441f
Cext_5409 PB.$5934.met3 VDD.$60.li1 0.00329468f
Cext_5410 PB.$5934.met3 VDD.$669.nwell 0.00235803f
Cext_5411 PB.$5934.met3 VDD.$678.nwell 0.00873749f
Cext_5412 PB.$5934.met3 VDD.$683.nwell 0.0104877f
Cext_5413 PB.$5934.met3 sky130_gnd 0.153236f
Cext_5414 PB.$5935.met3 VDD.$387.met1 0.00994051f
Cext_5415 PB.$5935.met3 VDD.$391.met1 0.00141722f
Cext_5416 PB.$5935.met3 VDD.$478.met2 0.00142412f
Cext_5417 PB.$5935.met3 VDD.$479.met2 0.0013606f
Cext_5418 PB.$5935.met3 VDD.$501.met3 0.0297154f
Cext_5419 PB.$5935.met3 VDD.$502.met3 0.00266201f
Cext_5420 PB.$5935.met3 VDD.$669.nwell 0.00167507f
Cext_5421 PB.$5935.met3 VDD.$679.nwell 0.00820757f
Cext_5422 PB.$5935.met3 VDD.$683.nwell 0.00579557f
Cext_5423 PB.$5935.met3 VDD.$705.nwell 0.00849658f
Cext_5424 PB.$5935.met3 VDD.P6.psdm 0.00203523f
Cext_5425 PB.$5935.met3 sky130_gnd 0.283418f
Cext_5426 PB.$5936.met3 TAIL.$340.met3 0.0220086f
Cext_5427 PB.$5936.met3 TAIL.$341.met3 0.0290929f
Cext_5428 PB.$5936.met3 VSS.$380.met2 0.112017f
Cext_5429 PB.$5936.met3 VSS.$422.met3 0.00308333f
Cext_5430 PB.$5936.met3 sky130_gnd 0.726899f
Cext_5431 PB.$5937.met3 VDD.$125.li1 0.0114348f
Cext_5432 PB.$5937.met3 VDD.$129.li1 0.00269146f
Cext_5433 PB.$5937.met3 VDD.$401.met1 0.00113841f
Cext_5434 PB.$5937.met3 VDD.$411.met1 0.00969816f
Cext_5435 PB.$5937.met3 VDD.$415.met1 0.0011116f
Cext_5436 PB.$5937.met3 VDD.$481.met2 0.00359378f
Cext_5437 PB.$5937.met3 VDD.$483.met2 0.00134359f
Cext_5438 PB.$5937.met3 VDD.$502.met3 0.0392065f
Cext_5439 PB.$5937.met3 VDD.$503.met3 0.00266201f
Cext_5440 PB.$5937.met3 VDD.$691.nwell 0.00404234f
Cext_5441 PB.$5937.met3 VDD.$701.nwell 0.0164035f
Cext_5442 PB.$5937.met3 VDD.$705.nwell 0.0121441f
Cext_5443 PB.$5937.met3 VDD.$727.nwell 0.00737812f
Cext_5444 PB.$5937.met3 VDD.P5.nwell 0.00100195f
Cext_5445 PB.$5937.met3 VDD.P5.psdm 0.00252425f
Cext_5446 PB.$5937.met3 VREF.$76.met1 0.00797407f
Cext_5447 PB.$5937.met3 VREF.P0.psdm 0.00135592f
Cext_5448 PB.$5937.met3 sky130_gnd 0.3816f
Cext_5449 PB.$5938.met3 VDD.$204.li1 0.00152344f
Cext_5450 PB.$5938.met3 VDD.$248.li1 0.00302663f
Cext_5451 PB.$5938.met3 VDD.$249.li1 0.00120188f
Cext_5452 PB.$5938.met3 VDD.$250.li1 0.00237515f
Cext_5453 PB.$5938.met3 VDD.$272.li1 0.00345765f
Cext_5454 PB.$5938.met3 VDD.$274.li1 0.00137698f
Cext_5455 PB.$5938.met3 VDD.$420.met1 0.00346158f
Cext_5456 PB.$5938.met3 VDD.$421.met1 0.0013729f
Cext_5457 PB.$5938.met3 VDD.$444.met1 0.00700589f
Cext_5458 PB.$5938.met3 VDD.$445.met1 0.00324233f
Cext_5459 PB.$5938.met3 VDD.$455.met1 0.00233986f
Cext_5460 PB.$5938.met3 VDD.$486.met2 0.00944717f
Cext_5461 PB.$5938.met3 VDD.$487.met2 0.00204566f
Cext_5462 PB.$5938.met3 VDD.$488.met2 0.0516386f
Cext_5463 PB.$5938.met3 VDD.$489.met2 0.00959735f
Cext_5464 PB.$5938.met3 VDD.$503.met3 0.127444f
Cext_5465 PB.$5938.met3 VDD.$504.met3 0.260136f
Cext_5466 PB.$5938.met3 VDD.$728.nwell 0.0126692f
Cext_5467 PB.$5938.met3 VDD.$730.nwell 0.00257987f
Cext_5468 PB.$5938.met3 sky130_gnd 0.158314f
Cext_5469 PB.$5939.met3 VDD.$193.li1 0.0114662f
Cext_5470 PB.$5939.met3 VDD.$196.li1 0.00327598f
Cext_5471 PB.$5939.met3 VDD.$432.met1 0.00583428f
Cext_5472 PB.$5939.met3 VDD.$433.met1 0.0024919f
Cext_5473 PB.$5939.met3 VDD.$437.met1 0.00259318f
Cext_5474 PB.$5939.met3 VDD.$441.met1 0.00127082f
Cext_5475 PB.$5939.met3 VDD.$484.met2 0.00278334f
Cext_5476 PB.$5939.met3 VDD.$485.met2 0.0013606f
Cext_5477 PB.$5939.met3 VDD.$503.met3 0.0246189f
Cext_5478 PB.$5939.met3 VDD.$713.nwell 0.0023562f
Cext_5479 PB.$5939.met3 VDD.$722.nwell 0.00417367f
Cext_5480 PB.$5939.met3 VDD.$723.nwell 0.0124826f
Cext_5481 PB.$5939.met3 VDD.$727.nwell 0.0124891f
Cext_5482 PB.$5939.met3 VDD.$749.nwell 0.00328766f
Cext_5483 PB.$5939.met3 VDD.P4.psdm 0.00233751f
Cext_5484 PB.$5939.met3 VREF.$76.met1 0.00348866f
Cext_5485 PB.$5939.met3 VREF.P0.psdm 0.00222386f
Cext_5486 PB.$5939.met3 sky130_gnd 0.259687f
Cext_5487 PB.$5940.met3 net2.$91.met3 0.00637931f
Cext_5488 PB.$5940.met3 VDD.$508.met3 0.01f
Cext_5489 PB.$5940.met3 sky130_gnd 0.0498328f
Cext_5490 PB.$5942.met3 S 0.0033221f
Cext_5491 PB.$5942.met3 S.$31.met2 0.00591065f
Cext_5492 PB.$5942.met3 VREF.$102.met2 0.00364459f
Cext_5493 PB.$5942.met3 VREF.$108.met3 0.220827f
Cext_5494 PB.$5942.met3 VREF.$111.poly 0.00112993f
Cext_5495 PB.$5942.met3 VSS 0.00115431f
Cext_5496 PB.$5942.met3 VSS.$422.met3 0.025092f
Cext_5497 PB.$5942.met3 VSS.$424.met3 0.0559118f
Cext_5498 PB.$5942.met3 sky130_gnd 0.693765f
Cext_5499 PB.$5943.met3 S.$25.met1 0.00200187f
Cext_5500 PB.$5943.met3 S.$27.met1 0.00189678f
Cext_5501 PB.$5943.met3 S.$35.met3 0.167041f
Cext_5502 PB.$5943.met3 S.$40.poly 0.00134013f
Cext_5503 PB.$5943.met3 S.P0.poly 0.00115125f
Cext_5504 PB.$5943.met3 VSS.$119.li1 0.00395107f
Cext_5505 PB.$5943.met3 VSS.$405.met2 0.00122397f
Cext_5506 PB.$5943.met3 VSS.$406.met2 0.0119631f
Cext_5507 PB.$5943.met3 VSS.$408.met2 0.0224088f
Cext_5508 PB.$5943.met3 VSS.$409.met2 0.0388444f
Cext_5509 PB.$5943.met3 VSS.$424.met3 0.0011934f
Cext_5510 PB.$5943.met3 VSS.$426.met3 0.00828725f
Cext_5511 PB.$5943.met3 VSS.$428.met3 0.0729766f
Cext_5512 PB.$5943.met3 sky130_gnd 0.0851408f
Cext_5513 PB.$5944.met3 S.$27.met1 0.00115377f
Cext_5514 PB.$5944.met3 S.$35.met3 0.167062f
Cext_5515 PB.$5944.met3 S.$40.poly 0.0023734f
Cext_5516 PB.$5944.met3 VSS.$409.met2 0.0175907f
Cext_5517 PB.$5944.met3 VSS.$428.met3 0.0480704f
Cext_5518 PB.$5944.met3 VSS.$429.met3 0.0333487f
Cext_5519 PB.$5944.met3 sky130_gnd 0.119273f
Cext_5520 PB.$5945.met3 VDD.$294.li1 0.00510657f
Cext_5521 PB.$5945.met3 VDD.$295.li1 0.00222793f
Cext_5522 PB.$5945.met3 VDD.$296.li1 0.00287509f
Cext_5523 PB.$5945.met3 VDD.$306.li1 0.0055675f
Cext_5524 PB.$5945.met3 VDD.$308.li1 0.00234003f
Cext_5525 PB.$5945.met3 VDD.$330.li1 0.00217492f
Cext_5526 PB.$5945.met3 VDD.$458.met1 0.00522932f
Cext_5527 PB.$5945.met3 VDD.$459.met1 0.00901731f
Cext_5528 PB.$5945.met3 VDD.$460.met1 0.00444523f
Cext_5529 PB.$5945.met3 VDD.$461.met1 0.00353179f
Cext_5530 PB.$5945.met3 VDD.$490.met2 0.00351592f
Cext_5531 PB.$5945.met3 VDD.$491.met2 0.0132896f
Cext_5532 PB.$5945.met3 VDD.$492.met2 0.0637696f
Cext_5533 PB.$5945.met3 VDD.$494.met2 0.00563126f
Cext_5534 PB.$5945.met3 VDD.$495.met2 0.00738958f
Cext_5535 PB.$5945.met3 VDD.$504.met3 0.0390556f
Cext_5536 PB.$5945.met3 VDD.$505.met3 0.258539f
Cext_5537 PB.$5945.met3 VDD.$506.met3 0.0895171f
Cext_5538 PB.$5945.met3 VDD.$507.met3 0.00959089f
Cext_5539 PB.$5945.met3 VDD.$750.nwell 0.0126341f
Cext_5540 PB.$5945.met3 VDD.$761.nwell 0.00259157f
Cext_5541 PB.$5945.met3 sky130_gnd 0.16006f
Cext_5542 PB.$5946.met4 net1.$621.met3 0.00115278f
Cext_5543 PB.$5946.met4 net2.$91.met3 0.00294653f
Cext_5544 PB.$5946.met4 VDD.$508.met3 0.0145004f
Cext_5545 PB.$5946.met4 sky130_gnd 0.103383f
Cext_5546 PB.$5947.met4 net1.$621.met3 0.00132158f
Cext_5547 PB.$5947.met4 net2.$68.met1 0.0107151f
Cext_5548 PB.$5947.met4 net2.$91.met3 0.00307042f
Cext_5549 PB.$5947.met4 net2.P0.li1 0.00378588f
Cext_5550 PB.$5947.met4 VDD.$508.met3 0.052268f
Cext_5551 PB.$5947.met4 VDD.P0.met3 0.361183f
Cext_5552 PB.$5947.met4 VSS.$116.li1 0.0131233f
Cext_5553 PB.$5947.met4 VSS.P16.li1 0.0144951f
Cext_5554 PB.$5947.met4 sky130_gnd 0.998046f
Cext_5555 PB.$6021.met4 net2.$91.met3 0.00114379f
Cext_5556 PB.$6021.met4 VDD.$508.met3 0.00507695f
Cext_5557 PB.$6021.met4 VDD.P0.met3 0.00507695f
Cext_5558 PB.$6021.met4 sky130_gnd 0.0247168f
Cext_5559 PB.$6095.met4 net2.$91.met3 0.0012773f
Cext_5560 PB.$6095.met4 VDD.$508.met3 0.00507695f
Cext_5561 PB.$6095.met4 VDD.P0.met3 0.00507695f
Cext_5562 PB.$6095.met4 sky130_gnd 0.0244265f
Cext_5563 PB.$6169.met4 net2.$91.met3 0.00104366f
Cext_5564 PB.$6169.met4 VDD.$508.met3 0.00507695f
Cext_5565 PB.$6169.met4 VDD.P0.met3 0.00507695f
Cext_5566 PB.$6169.met4 sky130_gnd 0.0249345f
Cext_5567 PB.$6243.met4 net2.$91.met3 0.0012773f
Cext_5568 PB.$6243.met4 VDD.$508.met3 0.00507695f
Cext_5569 PB.$6243.met4 VDD.P0.met3 0.00507695f
Cext_5570 PB.$6243.met4 sky130_gnd 0.0244265f
Cext_5571 PB.$6317.met4 net2.$91.met3 0.00114379f
Cext_5572 PB.$6317.met4 VDD.$508.met3 0.00507695f
Cext_5573 PB.$6317.met4 VDD.P0.met3 0.00507695f
Cext_5574 PB.$6317.met4 sky130_gnd 0.0247168f
Cext_5575 PB.$6391.met4 net2.$91.met3 0.00114379f
Cext_5576 PB.$6391.met4 VDD.$508.met3 0.00507695f
Cext_5577 PB.$6391.met4 VDD.P0.met3 0.00507695f
Cext_5578 PB.$6391.met4 sky130_gnd 0.0247168f
Cext_5579 PB.$6465.met4 net2.$91.met3 0.0012773f
Cext_5580 PB.$6465.met4 VDD.$508.met3 0.00507695f
Cext_5581 PB.$6465.met4 VDD.P0.met3 0.00507695f
Cext_5582 PB.$6465.met4 sky130_gnd 0.0244265f
Cext_5583 PB.$6539.met4 net2.$91.met3 0.00104366f
Cext_5584 PB.$6539.met4 VDD.$508.met3 0.00507695f
Cext_5585 PB.$6539.met4 VDD.P0.met3 0.00507695f
Cext_5586 PB.$6539.met4 sky130_gnd 0.0249345f
Cext_5587 PB.$6613.met4 net2.$91.met3 0.0012773f
Cext_5588 PB.$6613.met4 VDD.$508.met3 0.00507695f
Cext_5589 PB.$6613.met4 VDD.P0.met3 0.00507695f
Cext_5590 PB.$6613.met4 sky130_gnd 0.0244265f
Cext_5591 PB.$666.capm VDD.$508.met3 2.89459f
Cext_5592 PB.$666.capm VDD.P0.met3 21.2457f
Cext_5593 PB.$6687.met4 net2.$91.met3 0.00114379f
Cext_5594 PB.$6687.met4 VDD.$508.met3 0.00507695f
Cext_5595 PB.$6687.met4 VDD.P0.met3 0.00507695f
Cext_5596 PB.$6687.met4 sky130_gnd 0.0247168f
Cext_5597 PB.$6761.met4 net2.$91.met3 0.00114379f
Cext_5598 PB.$6761.met4 VDD.$508.met3 0.00507695f
Cext_5599 PB.$6761.met4 VDD.P0.met3 0.00507695f
Cext_5600 PB.$6761.met4 sky130_gnd 0.0247168f
Cext_5601 PB.$6835.met4 net2.$91.met3 0.0012773f
Cext_5602 PB.$6835.met4 VDD.$508.met3 0.00507695f
Cext_5603 PB.$6835.met4 VDD.P0.met3 0.00507695f
Cext_5604 PB.$6835.met4 sky130_gnd 0.0244265f
Cext_5605 PB.$6909.met4 net2.$91.met3 0.00104366f
Cext_5606 PB.$6909.met4 VDD.$508.met3 0.00507695f
Cext_5607 PB.$6909.met4 VDD.P0.met3 0.00507695f
Cext_5608 PB.$6909.met4 sky130_gnd 0.0249345f
Cext_5609 PB.$6983.met4 net2.$91.met3 0.0012773f
Cext_5610 PB.$6983.met4 VDD.$508.met3 0.00507695f
Cext_5611 PB.$6983.met4 VDD.P0.met3 0.00507695f
Cext_5612 PB.$6983.met4 sky130_gnd 0.0244265f
Cext_5613 PB.$7057.met4 net2.$91.met3 0.00114379f
Cext_5614 PB.$7057.met4 VDD.$508.met3 0.00507695f
Cext_5615 PB.$7057.met4 VDD.P0.met3 0.00507695f
Cext_5616 PB.$7057.met4 sky130_gnd 0.0247168f
Cext_5617 PB.$7131.met4 net2.$91.met3 0.00114379f
Cext_5618 PB.$7131.met4 VDD.$508.met3 0.00507695f
Cext_5619 PB.$7131.met4 VDD.P0.met3 0.00507695f
Cext_5620 PB.$7131.met4 sky130_gnd 0.0247168f
Cext_5621 PB.$7205.met4 net2.$91.met3 0.0012773f
Cext_5622 PB.$7205.met4 VDD.$508.met3 0.00507695f
Cext_5623 PB.$7205.met4 VDD.P0.met3 0.00507695f
Cext_5624 PB.$7205.met4 sky130_gnd 0.0244265f
Cext_5625 PB.$7279.met4 net2.$91.met3 0.00104366f
Cext_5626 PB.$7279.met4 VDD.$508.met3 0.00507695f
Cext_5627 PB.$7279.met4 VDD.P0.met3 0.00507695f
Cext_5628 PB.$7279.met4 sky130_gnd 0.0249345f
Cext_5629 PB.$7353.met4 net2.$91.met3 0.0012773f
Cext_5630 PB.$7353.met4 VDD.$508.met3 0.00507695f
Cext_5631 PB.$7353.met4 VDD.P0.met3 0.00507695f
Cext_5632 PB.$7353.met4 sky130_gnd 0.0244265f
Cext_5633 PB.$740.capm VDD.$508.met3 2.94736f
Cext_5634 PB.$740.capm VDD.P0.met3 21.1929f
Cext_5635 PB.$7427.met4 net2.$91.met3 0.00114379f
Cext_5636 PB.$7427.met4 VDD.$508.met3 0.00507695f
Cext_5637 PB.$7427.met4 VDD.P0.met3 0.00507695f
Cext_5638 PB.$7427.met4 sky130_gnd 0.0247168f
Cext_5639 PB.$7501.met4 net2.$91.met3 0.00114379f
Cext_5640 PB.$7501.met4 VDD.$508.met3 0.00507695f
Cext_5641 PB.$7501.met4 VDD.P0.met3 0.00507695f
Cext_5642 PB.$7501.met4 sky130_gnd 0.0247168f
Cext_5643 PB.$7575.met4 net2.$91.met3 0.0012773f
Cext_5644 PB.$7575.met4 VDD.$508.met3 0.00507695f
Cext_5645 PB.$7575.met4 VDD.P0.met3 0.00507695f
Cext_5646 PB.$7575.met4 sky130_gnd 0.0244265f
Cext_5647 PB.$7649.met4 net2.$91.met3 0.00104366f
Cext_5648 PB.$7649.met4 VDD.$508.met3 0.00507695f
Cext_5649 PB.$7649.met4 VDD.P0.met3 0.00507695f
Cext_5650 PB.$7649.met4 sky130_gnd 0.0249345f
Cext_5651 PB.$7723.met4 net2.$91.met3 0.0012773f
Cext_5652 PB.$7723.met4 VDD.$508.met3 0.00507695f
Cext_5653 PB.$7723.met4 VDD.P0.met3 0.00507695f
Cext_5654 PB.$7723.met4 sky130_gnd 0.0244265f
Cext_5655 PB.$7797.met4 net2.$91.met3 0.00114379f
Cext_5656 PB.$7797.met4 VDD.$508.met3 0.00507695f
Cext_5657 PB.$7797.met4 VDD.P0.met3 0.00507695f
Cext_5658 PB.$7797.met4 sky130_gnd 0.0247168f
Cext_5659 PB.$7871.met4 net2.$91.met3 0.00114379f
Cext_5660 PB.$7871.met4 VDD.$508.met3 0.00507695f
Cext_5661 PB.$7871.met4 VDD.P0.met3 0.00507695f
Cext_5662 PB.$7871.met4 sky130_gnd 0.0247168f
Cext_5663 PB.$7945.met4 net2.$91.met3 0.0012773f
Cext_5664 PB.$7945.met4 VDD.$508.met3 0.00507695f
Cext_5665 PB.$7945.met4 VDD.P0.met3 0.00507695f
Cext_5666 PB.$7945.met4 sky130_gnd 0.0244265f
Cext_5667 PB.$8019.met4 net2.$91.met3 0.00104366f
Cext_5668 PB.$8019.met4 VDD.$508.met3 0.00507695f
Cext_5669 PB.$8019.met4 VDD.P0.met3 0.00507695f
Cext_5670 PB.$8019.met4 sky130_gnd 0.0249345f
Cext_5671 PB.$8093.met4 net2.$91.met3 0.0012773f
Cext_5672 PB.$8093.met4 VDD.$508.met3 0.00507695f
Cext_5673 PB.$8093.met4 VDD.P0.met3 0.00507695f
Cext_5674 PB.$8093.met4 sky130_gnd 0.0244265f
Cext_5675 PB.$814.capm VDD.$508.met3 3.00012f
Cext_5676 PB.$814.capm VDD.P0.met3 21.1401f
Cext_5677 PB.$8167.met4 net2.$91.met3 0.00114379f
Cext_5678 PB.$8167.met4 VDD.$508.met3 0.00507695f
Cext_5679 PB.$8167.met4 VDD.P0.met3 0.00507695f
Cext_5680 PB.$8167.met4 sky130_gnd 0.0247168f
Cext_5681 PB.$8241.met4 net2.$91.met3 0.00114379f
Cext_5682 PB.$8241.met4 VDD.$508.met3 0.00507695f
Cext_5683 PB.$8241.met4 VDD.P0.met3 0.00507695f
Cext_5684 PB.$8241.met4 sky130_gnd 0.0247168f
Cext_5685 PB.$8315.met4 net2.$91.met3 0.0012773f
Cext_5686 PB.$8315.met4 VDD.$508.met3 0.00507695f
Cext_5687 PB.$8315.met4 VDD.P0.met3 0.00507695f
Cext_5688 PB.$8315.met4 sky130_gnd 0.0244265f
Cext_5689 PB.$8389.met4 net2.$91.met3 0.00104366f
Cext_5690 PB.$8389.met4 VDD.$508.met3 0.00507695f
Cext_5691 PB.$8389.met4 VDD.P0.met3 0.00507695f
Cext_5692 PB.$8389.met4 sky130_gnd 0.0249345f
Cext_5693 PB.$8463.met4 net2.$91.met3 0.0012773f
Cext_5694 PB.$8463.met4 VDD.$508.met3 0.00507695f
Cext_5695 PB.$8463.met4 VDD.P0.met3 0.00507695f
Cext_5696 PB.$8463.met4 sky130_gnd 0.0244265f
Cext_5697 PB.$8537.met4 net2.$91.met3 0.00114379f
Cext_5698 PB.$8537.met4 VDD.$508.met3 0.00507695f
Cext_5699 PB.$8537.met4 VDD.P0.met3 0.00507695f
Cext_5700 PB.$8537.met4 sky130_gnd 0.0247168f
Cext_5701 PB.$8611.met4 net2.$91.met3 0.00114379f
Cext_5702 PB.$8611.met4 VDD.$508.met3 0.00507695f
Cext_5703 PB.$8611.met4 VDD.P0.met3 0.00507695f
Cext_5704 PB.$8611.met4 sky130_gnd 0.0247168f
Cext_5705 PB.$8685.met4 net2.$91.met3 0.0012773f
Cext_5706 PB.$8685.met4 VDD.$508.met3 0.00507695f
Cext_5707 PB.$8685.met4 VDD.P0.met3 0.00507695f
Cext_5708 PB.$8685.met4 sky130_gnd 0.0244265f
Cext_5709 PB.$8759.met4 net2.$91.met3 0.00104366f
Cext_5710 PB.$8759.met4 VDD.$508.met3 0.00507695f
Cext_5711 PB.$8759.met4 VDD.P0.met3 0.00507695f
Cext_5712 PB.$8759.met4 sky130_gnd 0.0249345f
Cext_5713 PB.$8833.met4 net2.$91.met3 0.0012773f
Cext_5714 PB.$8833.met4 VDD.$508.met3 0.00507695f
Cext_5715 PB.$8833.met4 VDD.P0.met3 0.00507695f
Cext_5716 PB.$8833.met4 sky130_gnd 0.0244265f
Cext_5717 PB.$888.capm VDD.$508.met3 3.05289f
Cext_5718 PB.$888.capm VDD.P0.met3 21.0874f
Cext_5719 PB.$8907.met4 net2.$91.met3 0.00114379f
Cext_5720 PB.$8907.met4 VDD.$508.met3 0.00507695f
Cext_5721 PB.$8907.met4 VDD.$511.met3 0.00442685f
Cext_5722 PB.$8907.met4 sky130_gnd 0.0247168f
Cext_5723 PB.$8981.met4 net2.$91.met3 0.00114379f
Cext_5724 PB.$8981.met4 VDD.$508.met3 0.00507695f
Cext_5725 PB.$8981.met4 VDD.$511.met3 0.00507695f
Cext_5726 PB.$8981.met4 sky130_gnd 0.0247168f
Cext_5727 PB.$9055.met4 net2.$91.met3 0.0012773f
Cext_5728 PB.$9055.met4 VDD.$508.met3 0.00507695f
Cext_5729 PB.$9055.met4 VDD.$511.met3 0.00507695f
Cext_5730 PB.$9055.met4 sky130_gnd 0.0244265f
Cext_5731 PB.$9129.met4 net2.$91.met3 0.00104366f
Cext_5732 PB.$9129.met4 VDD.$508.met3 0.00507695f
Cext_5733 PB.$9129.met4 VDD.$511.met3 0.00507695f
Cext_5734 PB.$9129.met4 sky130_gnd 0.0249345f
Cext_5735 PB.$9203.met4 net2.$91.met3 0.0012773f
Cext_5736 PB.$9203.met4 VDD.$497.met2 0.00216059f
Cext_5737 PB.$9203.met4 VDD.$508.met3 0.00533571f
Cext_5738 PB.$9203.met4 VDD.$511.met3 0.00507695f
Cext_5739 PB.$9203.met4 sky130_gnd 0.0204408f
Cext_5740 PB.$9277.met4 net2.$91.met3 0.00114379f
Cext_5741 PB.$9277.met4 VDD.$508.met3 0.00605568f
Cext_5742 PB.$9277.met4 VDD.$511.met3 0.00507695f
Cext_5743 PB.$9277.met4 sky130_gnd 0.022856f
Cext_5744 PB.$9351.met4 net2.$91.met3 0.00114379f
Cext_5745 PB.$9351.met4 VDD.$508.met3 0.00537861f
Cext_5746 PB.$9351.met4 VDD.$511.met3 0.00507695f
Cext_5747 PB.$9351.met4 sky130_gnd 0.0239185f
Cext_5748 PB.$9425.met4 net2.$91.met3 0.0012773f
Cext_5749 PB.$9425.met4 VDD.$508.met3 0.00541329f
Cext_5750 PB.$9425.met4 VDD.$511.met3 0.00507695f
Cext_5751 PB.$9425.met4 sky130_gnd 0.0235369f
Cext_5752 PB.$9499.met4 net2.$91.met3 0.00104366f
Cext_5753 PB.$9499.met4 VDD.$508.met3 0.00535259f
Cext_5754 PB.$9499.met4 VDD.$511.met3 0.00507695f
Cext_5755 PB.$9499.met4 sky130_gnd 0.0242046f
Cext_5756 PB.$9573.met4 net2.$91.met3 0.0012773f
Cext_5757 PB.$9573.met4 VDD.$508.met3 0.00541329f
Cext_5758 PB.$9573.met4 VDD.$511.met3 0.00507695f
Cext_5759 PB.$9573.met4 sky130_gnd 0.0235369f
Cext_5760 PB.$9647.met4 net2.$91.met3 0.00114379f
Cext_5761 PB.$9647.met4 VDD.$508.met3 0.00537861f
Cext_5762 PB.$9647.met4 VDD.$511.met3 0.00507695f
Cext_5763 PB.$9647.met4 sky130_gnd 0.0239185f
Cext_5764 PB.$9721.met4 net2.$92.met3 0.00114379f
Cext_5765 PB.$9721.met4 VDD.$508.met3 0.00537861f
Cext_5766 PB.$9721.met4 VDD.$511.met3 0.00507695f
Cext_5767 PB.$9721.met4 sky130_gnd 0.0239185f
Cext_5768 PB.$9795.met4 net2.$92.met3 0.0012773f
Cext_5769 PB.$9795.met4 VDD.$508.met3 0.00541329f
Cext_5770 PB.$9795.met4 VDD.$511.met3 0.00507695f
Cext_5771 PB.$9795.met4 sky130_gnd 0.0235369f
Cext_5772 PB.$9869.met4 net2.$92.met3 0.00104366f
Cext_5773 PB.$9869.met4 VDD.$508.met3 0.00535259f
Cext_5774 PB.$9869.met4 VDD.$511.met3 0.00507695f
Cext_5775 PB.$9869.met4 sky130_gnd 0.0242046f
Cext_5776 PB.P0.capm VDD.P0.met3 0.16f
Cext_5777 PB.P0.poly VDD.$10.li1 0.0163656f
Cext_5778 PB.P0.poly VDD.$12.li1 0.0177889f
Cext_5779 PB.P0.poly VDD.$14.li1 0.0181392f
Cext_5780 PB.P0.poly VDD.$16.li1 0.0181392f
Cext_5781 PB.P0.poly VDD.$18.li1 0.0181392f
Cext_5782 PB.P0.poly VDD.$20.li1 0.0181392f
Cext_5783 PB.P0.poly VDD.$22.li1 0.0181392f
Cext_5784 PB.P0.poly VDD.$24.li1 0.0181392f
Cext_5785 PB.P0.poly VDD.$26.li1 0.0181392f
Cext_5786 PB.P0.poly VDD.$28.li1 0.0181392f
Cext_5787 PB.P0.poly VDD.$30.li1 0.0177889f
Cext_5788 PB.P0.poly VDD.$32.li1 0.0163656f
Cext_5789 PB.P0.poly VDD.$34.li1 0.00102285f
Cext_5790 PB.P0.poly VDD.$350.met1 0.0149101f
Cext_5791 PB.P0.poly VDD.$351.met1 0.0150866f
Cext_5792 PB.P0.poly VDD.$352.met1 0.0151301f
Cext_5793 PB.P0.poly VDD.$353.met1 0.0151301f
Cext_5794 PB.P0.poly VDD.$354.met1 0.0151301f
Cext_5795 PB.P0.poly VDD.$355.met1 0.0151301f
Cext_5796 PB.P0.poly VDD.$356.met1 0.0151301f
Cext_5797 PB.P0.poly VDD.$357.met1 0.0151301f
Cext_5798 PB.P0.poly VDD.$358.met1 0.0151301f
Cext_5799 PB.P0.poly VDD.$359.met1 0.0151301f
Cext_5800 PB.P0.poly VDD.$360.met1 0.0150866f
Cext_5801 PB.P0.poly VDD.$361.met1 0.0149101f
Cext_5802 PB.P0.poly VDD.$478.met2 0.0206522f
Cext_5803 PB.P0.poly VDD.$479.met2 0.0156035f
Cext_5804 PB.P0.poly VDD.$500.met3 0.156403f
Cext_5805 PB.P0.poly VDD.$501.met3 0.0247533f
Cext_5806 PB.P0.poly VDD.$51.li1 0.00103443f
Cext_5807 PB.P0.poly VDD.$52.li1 0.00103443f
Cext_5808 PB.P0.poly VDD.$53.li1 0.00103443f
Cext_5809 PB.P0.poly VDD.$56.li1 0.00103443f
Cext_5810 PB.P0.poly VDD.$57.li1 0.00103443f
Cext_5811 PB.P0.poly VDD.$58.li1 0.00103443f
Cext_5812 PB.P0.poly VDD.$66.li1 0.00237654f
Cext_5813 PB.P0.poly VDD.$8.li1 0.00102285f
Cext_5814 PB.P0.psdm VDD.$506.met3 0.00268269f
Cext_5815 PB.P1.nsdm VSS.$13.li1 0.0363487f
Cext_5816 PB.P1.nsdm VSS.$377.met2 0.00302535f
Cext_5817 PB.P1.nsdm VSS.$417.met3 0.00598812f
Cext_5818 PB.P1.poly VDD.$212.li1 0.00102285f
Cext_5819 PB.P1.poly VDD.$214.li1 0.0163656f
Cext_5820 PB.P1.poly VDD.$216.li1 0.0177889f
Cext_5821 PB.P1.poly VDD.$218.li1 0.0181392f
Cext_5822 PB.P1.poly VDD.$220.li1 0.0181392f
Cext_5823 PB.P1.poly VDD.$222.li1 0.0181392f
Cext_5824 PB.P1.poly VDD.$224.li1 0.0180653f
Cext_5825 PB.P1.poly VDD.$226.li1 0.0182888f
Cext_5826 PB.P1.poly VDD.$228.li1 0.0181392f
Cext_5827 PB.P1.poly VDD.$230.li1 0.0181392f
Cext_5828 PB.P1.poly VDD.$232.li1 0.0181392f
Cext_5829 PB.P1.poly VDD.$234.li1 0.0177889f
Cext_5830 PB.P1.poly VDD.$236.li1 0.0163656f
Cext_5831 PB.P1.poly VDD.$238.li1 0.00102285f
Cext_5832 PB.P1.poly VDD.$255.li1 0.00103443f
Cext_5833 PB.P1.poly VDD.$256.li1 0.00103443f
Cext_5834 PB.P1.poly VDD.$257.li1 0.00103443f
Cext_5835 PB.P1.poly VDD.$261.li1 0.00103443f
Cext_5836 PB.P1.poly VDD.$262.li1 0.00103443f
Cext_5837 PB.P1.poly VDD.$270.li1 0.00233556f
Cext_5838 PB.P1.poly VDD.$425.met1 0.0149101f
Cext_5839 PB.P1.poly VDD.$426.met1 0.0150866f
Cext_5840 PB.P1.poly VDD.$427.met1 0.0151301f
Cext_5841 PB.P1.poly VDD.$428.met1 0.0151301f
Cext_5842 PB.P1.poly VDD.$429.met1 0.0151301f
Cext_5843 PB.P1.poly VDD.$430.met1 0.0150079f
Cext_5844 PB.P1.poly VDD.$431.met1 0.016005f
Cext_5845 PB.P1.poly VDD.$432.met1 0.0151301f
Cext_5846 PB.P1.poly VDD.$433.met1 0.0151301f
Cext_5847 PB.P1.poly VDD.$434.met1 0.0151301f
Cext_5848 PB.P1.poly VDD.$435.met1 0.0150866f
Cext_5849 PB.P1.poly VDD.$436.met1 0.0149101f
Cext_5850 PB.P1.poly VDD.$484.met2 0.00795955f
Cext_5851 PB.P1.poly VDD.$485.met2 0.0102451f
Cext_5852 PB.P1.poly VDD.$487.met2 0.0670629f
Cext_5853 PB.P1.poly VDD.$489.met2 0.00224058f
Cext_5854 PB.P1.poly VDD.$503.met3 0.149373f
Cext_5855 PB.P1.poly VDD.$504.met3 0.0167277f
Cext_5856 PB.P2.poly VDD.$144.li1 0.00102285f
Cext_5857 PB.P2.poly VDD.$146.li1 0.0163656f
Cext_5858 PB.P2.poly VDD.$148.li1 0.0177889f
Cext_5859 PB.P2.poly VDD.$150.li1 0.0181392f
Cext_5860 PB.P2.poly VDD.$152.li1 0.0181392f
Cext_5861 PB.P2.poly VDD.$154.li1 0.0181392f
Cext_5862 PB.P2.poly VDD.$156.li1 0.0180653f
Cext_5863 PB.P2.poly VDD.$158.li1 0.0180653f
Cext_5864 PB.P2.poly VDD.$160.li1 0.0181392f
Cext_5865 PB.P2.poly VDD.$162.li1 0.0181392f
Cext_5866 PB.P2.poly VDD.$164.li1 0.0181392f
Cext_5867 PB.P2.poly VDD.$166.li1 0.0177889f
Cext_5868 PB.P2.poly VDD.$168.li1 0.0163656f
Cext_5869 PB.P2.poly VDD.$170.li1 0.00102285f
Cext_5870 PB.P2.poly VDD.$187.li1 0.00103443f
Cext_5871 PB.P2.poly VDD.$188.li1 0.00103443f
Cext_5872 PB.P2.poly VDD.$189.li1 0.00103443f
Cext_5873 PB.P2.poly VDD.$192.li1 0.00103443f
Cext_5874 PB.P2.poly VDD.$193.li1 0.00103443f
Cext_5875 PB.P2.poly VDD.$194.li1 0.00103443f
Cext_5876 PB.P2.poly VDD.$202.li1 0.00237654f
Cext_5877 PB.P2.poly VDD.$399.met1 0.0149101f
Cext_5878 PB.P2.poly VDD.$400.met1 0.0150866f
Cext_5879 PB.P2.poly VDD.$401.met1 0.0151301f
Cext_5880 PB.P2.poly VDD.$402.met1 0.0151301f
Cext_5881 PB.P2.poly VDD.$403.met1 0.0151301f
Cext_5882 PB.P2.poly VDD.$404.met1 0.0150079f
Cext_5883 PB.P2.poly VDD.$405.met1 0.0150323f
Cext_5884 PB.P2.poly VDD.$406.met1 0.0151301f
Cext_5885 PB.P2.poly VDD.$407.met1 0.0151301f
Cext_5886 PB.P2.poly VDD.$408.met1 0.0151301f
Cext_5887 PB.P2.poly VDD.$409.met1 0.0150866f
Cext_5888 PB.P2.poly VDD.$410.met1 0.0149101f
Cext_5889 PB.P2.poly VDD.$416.met1 0.00442902f
Cext_5890 PB.P2.poly VDD.$481.met2 0.0146745f
Cext_5891 PB.P2.poly VDD.$483.met2 0.100651f
Cext_5892 PB.P2.poly VDD.$484.met2 0.0229492f
Cext_5893 PB.P2.poly VDD.$485.met2 0.0147902f
Cext_5894 PB.P2.poly VDD.$502.met3 0.148106f
Cext_5895 PB.P2.poly VDD.$503.met3 0.0124942f
Cext_5896 PB.P2.poly VREF.$10.li1 0.0164102f
Cext_5897 PB.P2.poly VREF.$12.li1 0.0178335f
Cext_5898 PB.P2.poly VREF.$14.li1 0.0181838f
Cext_5899 PB.P2.poly VREF.$16.li1 0.0181838f
Cext_5900 PB.P2.poly VREF.$18.li1 0.0200476f
Cext_5901 PB.P2.poly VREF.$20.li1 0.0180851f
Cext_5902 PB.P2.poly VREF.$22.li1 0.0180653f
Cext_5903 PB.P2.poly VREF.$24.li1 0.0181665f
Cext_5904 PB.P2.poly VREF.$26.li1 0.0181838f
Cext_5905 PB.P2.poly VREF.$28.li1 0.0181838f
Cext_5906 PB.P2.poly VREF.$30.li1 0.0178335f
Cext_5907 PB.P2.poly VREF.$32.li1 0.0164102f
Cext_5908 PB.P2.poly VREF.$34.li1 0.00102285f
Cext_5909 PB.P2.poly VREF.$68.met1 0.0149101f
Cext_5910 PB.P2.poly VREF.$69.met1 0.0150866f
Cext_5911 PB.P2.poly VREF.$70.met1 0.0151301f
Cext_5912 PB.P2.poly VREF.$71.met1 0.0151301f
Cext_5913 PB.P2.poly VREF.$72.met1 0.0151301f
Cext_5914 PB.P2.poly VREF.$73.met1 0.0150079f
Cext_5915 PB.P2.poly VREF.$74.met1 0.0150323f
Cext_5916 PB.P2.poly VREF.$75.met1 0.0151927f
Cext_5917 PB.P2.poly VREF.$76.met1 0.0152326f
Cext_5918 PB.P2.poly VREF.$77.met1 0.0152326f
Cext_5919 PB.P2.poly VREF.$78.met1 0.0151891f
Cext_5920 PB.P2.poly VREF.$79.met1 0.0150126f
Cext_5921 PB.P2.poly VREF.$8.li1 0.00102285f
Cext_5922 PB.P3.poly VDD.$100.li1 0.0163656f
Cext_5923 PB.P3.poly VDD.$102.li1 0.00102285f
Cext_5924 PB.P3.poly VDD.$119.li1 0.00103443f
Cext_5925 PB.P3.poly VDD.$120.li1 0.00103443f
Cext_5926 PB.P3.poly VDD.$121.li1 0.00103443f
Cext_5927 PB.P3.poly VDD.$124.li1 0.00103443f
Cext_5928 PB.P3.poly VDD.$125.li1 0.00103443f
Cext_5929 PB.P3.poly VDD.$126.li1 0.00103443f
Cext_5930 PB.P3.poly VDD.$134.li1 0.00237654f
Cext_5931 PB.P3.poly VDD.$375.met1 0.0149101f
Cext_5932 PB.P3.poly VDD.$376.met1 0.0150866f
Cext_5933 PB.P3.poly VDD.$377.met1 0.0151301f
Cext_5934 PB.P3.poly VDD.$378.met1 0.0151301f
Cext_5935 PB.P3.poly VDD.$379.met1 0.0151301f
Cext_5936 PB.P3.poly VDD.$380.met1 0.0150079f
Cext_5937 PB.P3.poly VDD.$381.met1 0.0149101f
Cext_5938 PB.P3.poly VDD.$382.met1 0.0150445f
Cext_5939 PB.P3.poly VDD.$383.met1 0.0151301f
Cext_5940 PB.P3.poly VDD.$384.met1 0.0151301f
Cext_5941 PB.P3.poly VDD.$385.met1 0.0150866f
Cext_5942 PB.P3.poly VDD.$386.met1 0.0149101f
Cext_5943 PB.P3.poly VDD.$478.met2 0.0249205f
Cext_5944 PB.P3.poly VDD.$479.met2 0.070712f
Cext_5945 PB.P3.poly VDD.$481.met2 0.0212927f
Cext_5946 PB.P3.poly VDD.$483.met2 0.0157009f
Cext_5947 PB.P3.poly VDD.$501.met3 0.175341f
Cext_5948 PB.P3.poly VDD.$502.met3 0.00836165f
Cext_5949 PB.P3.poly VDD.$76.li1 0.00102285f
Cext_5950 PB.P3.poly VDD.$78.li1 0.0163656f
Cext_5951 PB.P3.poly VDD.$80.li1 0.0177889f
Cext_5952 PB.P3.poly VDD.$82.li1 0.0181392f
Cext_5953 PB.P3.poly VDD.$84.li1 0.0181392f
Cext_5954 PB.P3.poly VDD.$86.li1 0.0181392f
Cext_5955 PB.P3.poly VDD.$88.li1 0.0180653f
Cext_5956 PB.P3.poly VDD.$90.li1 0.0180653f
Cext_5957 PB.P3.poly VDD.$92.li1 0.0181392f
Cext_5958 PB.P3.poly VDD.$94.li1 0.0181392f
Cext_5959 PB.P3.poly VDD.$96.li1 0.0181392f
Cext_5960 PB.P3.poly VDD.$98.li1 0.0177889f
Cext_5961 S VREF.$108.met3 0.0329366f
Cext_5962 S VREF.$111.poly 0.00178716f
Cext_5963 S VREF.$52.li1 0.00383825f
Cext_5964 S VREF.$91.met1 0.00663706f
Cext_5965 S VSS.$115.li1 0.0169134f
Cext_5966 S VSS.$303.met1 0.00447609f
Cext_5967 S VSS.$401.met2 0.0318583f
Cext_5968 S VSS.$403.met2 0.0161285f
Cext_5969 S VSS.$406.met2 0.00193345f
Cext_5970 S VSS.$426.met3 0.0533456f
Cext_5971 S sky130_gnd 0.101898f
Cext_5972 S.$0.li1 VREF.$104.met2 0.00118916f
Cext_5973 S.$0.li1 VREF.P0.poly 0.0130836f
Cext_5974 S.$0.li1 VSS.$111.li1 0.00359597f
Cext_5975 S.$0.li1 VSS.$115.li1 0.0145924f
Cext_5976 S.$0.li1 sky130_gnd 0.00635633f
Cext_5977 S.$10.li1 sky130_gnd 0.0140353f
Cext_5978 S.$12.li1 sky130_gnd 0.0206882f
Cext_5979 S.$14.li1 sky130_gnd 0.0206882f
Cext_5980 S.$16.li1 VDD.$342.li1 0.0152347f
Cext_5981 S.$16.li1 VDD.$507.met3 0.00352135f
Cext_5982 S.$16.li1 VDD.$772.nwell 0.00474993f
Cext_5983 S.$16.li1 VSS.$519.poly 0.00142874f
Cext_5984 S.$16.li1 VSS.P0.poly 0.0157255f
Cext_5985 S.$16.li1 sky130_gnd 0.00876034f
Cext_5986 S.$18.met1 VREF.$104.met2 0.00365149f
Cext_5987 S.$18.met1 VREF.P0.poly 0.00759598f
Cext_5988 S.$18.met1 VSS.$115.li1 0.00441559f
Cext_5989 S.$18.met1 VSS.$301.met1 0.00545808f
Cext_5990 S.$18.met1 VSS.$303.met1 0.00185393f
Cext_5991 S.$18.met1 VSS.$307.met1 0.00121405f
Cext_5992 S.$18.met1 VSS.$424.met3 0.00109535f
Cext_5993 S.$18.met1 sky130_gnd 0.0131157f
Cext_5994 S.$19.met1 VREF.$104.met2 0.00320663f
Cext_5995 S.$19.met1 VREF.P0.poly 0.00759598f
Cext_5996 S.$19.met1 VSS.$115.li1 0.00132709f
Cext_5997 S.$19.met1 VSS.$302.met1 0.00553116f
Cext_5998 S.$19.met1 VSS.$424.met3 0.00198607f
Cext_5999 S.$19.met1 sky130_gnd 0.0129623f
Cext_6000 S.$2.li1 VREF.P0.poly 0.0135557f
Cext_6001 S.$2.li1 VSS.$113.li1 0.00359156f
Cext_6002 S.$2.li1 VSS.$115.li1 0.0149257f
Cext_6003 S.$2.li1 sky130_gnd 0.00635633f
Cext_6004 S.$20.met1 VSS.$115.li1 0.0128515f
Cext_6005 S.$20.met1 VSS.$303.met1 0.00786229f
Cext_6006 S.$20.met1 VSS.$403.met2 0.00129218f
Cext_6007 S.$20.met1 VSS.$426.met3 0.00105752f
Cext_6008 S.$20.met1 sky130_gnd 0.00795004f
Cext_6009 S.$21.met1 VREF.$108.met3 0.00219148f
Cext_6010 S.$21.met1 VREF.$91.met1 0.00132029f
Cext_6011 S.$21.met1 sky130_gnd 0.0273982f
Cext_6012 S.$22.met1 VSS.$307.met1 0.00276023f
Cext_6013 S.$22.met1 VSS.$308.met1 0.00352672f
Cext_6014 S.$22.met1 VSS.$405.met2 0.00208054f
Cext_6015 S.$22.met1 sky130_gnd 0.00382045f
Cext_6016 S.$23.met1 VSS.$308.met1 0.00593258f
Cext_6017 S.$23.met1 VSS.$403.met2 0.00403585f
Cext_6018 S.$23.met1 VSS.$405.met2 0.0170567f
Cext_6019 S.$23.met1 VSS.$407.met2 0.0121517f
Cext_6020 S.$23.met1 sky130_gnd 0.0194393f
Cext_6021 S.$24.met1 VREF.$108.met3 0.00133029f
Cext_6022 S.$24.met1 sky130_gnd 0.0143234f
Cext_6023 S.$25.met1 VSS.$405.met2 0.0115449f
Cext_6024 S.$25.met1 VSS.$409.met2 0.00108516f
Cext_6025 S.$25.met1 sky130_gnd 0.0143234f
Cext_6026 S.$26.met1 sky130_gnd 0.0222207f
Cext_6027 S.$27.met1 sky130_gnd 0.0222207f
Cext_6028 S.$28.met1 VDD.$498.met2 0.00109952f
Cext_6029 S.$28.met1 VDD.$507.met3 0.00833457f
Cext_6030 S.$28.met1 VDD.$772.nwell 0.00287681f
Cext_6031 S.$28.met1 VSS.$206.li1 0.00116322f
Cext_6032 S.$28.met1 VSS.$354.met1 0.00268702f
Cext_6033 S.$28.met1 VSS.$355.met1 0.00395506f
Cext_6034 S.$28.met1 VSS.$519.poly 0.00568044f
Cext_6035 S.$28.met1 VSS.P0.poly 0.0156517f
Cext_6036 S.$28.met1 sky130_gnd 0.00991529f
Cext_6037 S.$29.met1 VDD.$342.li1 0.00911019f
Cext_6038 S.$29.met1 VDD.$474.met1 0.0080305f
Cext_6039 S.$29.met1 VDD.$498.met2 0.00513126f
Cext_6040 S.$29.met1 VDD.$507.met3 0.00117641f
Cext_6041 S.$29.met1 VDD.$509.met3 0.00275365f
Cext_6042 S.$29.met1 VDD.$772.nwell 0.00452357f
Cext_6043 S.$29.met1 VSS.P0.poly 0.00419174f
Cext_6044 S.$29.met1 sky130_gnd 0.012639f
Cext_6045 S.$30.met2 VREF.$104.met2 0.0432897f
Cext_6046 S.$30.met2 VREF.$108.met3 0.00130828f
Cext_6047 S.$30.met2 VREF.$111.poly 0.00274804f
Cext_6048 S.$30.met2 VREF.$91.met1 0.00578292f
Cext_6049 S.$30.met2 VREF.P0.poly 0.00410099f
Cext_6050 S.$30.met2 VSS.$424.met3 0.00795164f
Cext_6051 S.$30.met2 VSS.$426.met3 0.0130577f
Cext_6052 S.$30.met2 sky130_gnd 0.0168f
Cext_6053 S.$31.met2 VREF.$108.met3 0.0332741f
Cext_6054 S.$31.met2 VREF.$89.met1 0.0012712f
Cext_6055 S.$31.met2 VSS.$307.met1 0.00437318f
Cext_6056 S.$31.met2 VSS.$403.met2 0.0147195f
Cext_6057 S.$31.met2 VSS.$406.met2 0.0309744f
Cext_6058 S.$31.met2 sky130_gnd 0.089081f
Cext_6059 S.$32.met2 VSS.$406.met2 0.0113372f
Cext_6060 S.$32.met2 sky130_gnd 0.00540283f
Cext_6061 S.$33.met2 VDD.$497.met2 0.129367f
Cext_6062 S.$33.met2 VDD.$499.met2 0.181928f
Cext_6063 S.$33.met2 VREF.$110.met3 0.00364459f
Cext_6064 S.$33.met2 VSS.$410.met2 0.0297479f
Cext_6065 S.$33.met2 sky130_gnd 0.571674f
Cext_6066 S.$34.met2 VDD.$342.li1 0.00190562f
Cext_6067 S.$34.met2 VDD.$496.met2 0.00109052f
Cext_6068 S.$34.met2 VDD.$498.met2 0.0340586f
Cext_6069 S.$34.met2 VDD.$499.met2 0.280773f
Cext_6070 S.$34.met2 VDD.$507.met3 0.0177258f
Cext_6071 S.$34.met2 VDD.$509.met3 0.0609183f
Cext_6072 S.$34.met2 VDD.$772.nwell 0.0101479f
Cext_6073 S.$34.met2 VDD.P0.nwell 0.00679154f
Cext_6074 S.$34.met2 VSS.$204.li1 0.00983204f
Cext_6075 S.$34.met2 VSS.$206.li1 0.00211111f
Cext_6076 S.$34.met2 VSS.$332.met1 0.00200758f
Cext_6077 S.$34.met2 VSS.$334.met1 0.0133231f
Cext_6078 S.$34.met2 VSS.$354.met1 0.0388948f
Cext_6079 S.$34.met2 VSS.$355.met1 0.0121772f
Cext_6080 S.$34.met2 VSS.$410.met2 0.00398486f
Cext_6081 S.$34.met2 VSS.$411.met2 0.033731f
Cext_6082 S.$34.met2 VSS.$497.poly 0.0105931f
Cext_6083 S.$34.met2 VSS.$499.poly 0.00198281f
Cext_6084 S.$34.met2 VSS.$519.poly 0.0129632f
Cext_6085 S.$34.met2 VSS.P0.poly 0.0206342f
Cext_6086 S.$34.met2 sky130_gnd 0.51507f
Cext_6087 S.$35.met3 VREF.$108.met3 0.406995f
Cext_6088 S.$35.met3 VSS.$119.li1 0.00415507f
Cext_6089 S.$35.met3 VSS.$309.met1 0.00189098f
Cext_6090 S.$35.met3 VSS.$405.met2 0.0133831f
Cext_6091 S.$35.met3 VSS.$406.met2 0.00165205f
Cext_6092 S.$35.met3 VSS.$409.met2 0.0159371f
Cext_6093 S.$35.met3 VSS.$429.met3 0.00935632f
Cext_6094 S.$35.met3 sky130_gnd 0.171396f
Cext_6095 S.$36.met3 VDD.$497.met2 0.0072428f
Cext_6096 S.$36.met3 VREF.$108.met3 0.17575f
Cext_6097 S.$36.met3 VREF.$110.met3 0.225083f
Cext_6098 S.$36.met3 VSS.$429.met3 0.0413693f
Cext_6099 S.$36.met3 sky130_gnd 0.472697f
Cext_6100 S.$39.poly VREF.$111.poly 0.00158266f
Cext_6101 S.$39.poly VSS.$308.met1 0.00119256f
Cext_6102 S.$39.poly VSS.$406.met2 0.00143821f
Cext_6103 S.$39.poly sky130_gnd 0.164519f
Cext_6104 S.$4.li1 VSS.$405.met2 0.0012223f
Cext_6105 S.$4.li1 sky130_gnd 0.01957f
Cext_6106 S.$40.poly VREF.P0.poly 0.00158266f
Cext_6107 S.$40.poly VSS.$308.met1 0.00149645f
Cext_6108 S.$40.poly VSS.$403.met2 0.00245642f
Cext_6109 S.$40.poly VSS.$405.met2 0.0047298f
Cext_6110 S.$40.poly VSS.$407.met2 0.00168706f
Cext_6111 S.$40.poly sky130_gnd 0.163727f
Cext_6112 S.$6.li1 VSS.$308.met1 0.00153259f
Cext_6113 S.$6.li1 VSS.$405.met2 0.00135405f
Cext_6114 S.$6.li1 VSS.$407.met2 0.00453299f
Cext_6115 S.$6.li1 sky130_gnd 0.01909f
Cext_6116 S.$8.li1 sky130_gnd 0.0140353f
Cext_6117 S.P0.nsdm VSS.$115.li1 0.00117883f
Cext_6118 S.P0.poly VSS.$117.li1 0.0126591f
Cext_6119 S.P0.poly VSS.$119.li1 0.00135524f
Cext_6120 S.P0.poly VSS.$307.met1 0.00214164f
Cext_6121 S.P0.poly VSS.$308.met1 0.00795075f
Cext_6122 S.P0.poly VSS.$405.met2 0.00393511f
Cext_6123 S.P0.poly sky130_gnd 0.00795833f
Cext_6124 TAIL VSS.$380.met2 0.0165596f
Cext_6125 TAIL sky130_gnd 0.0019285f
Cext_6126 TAIL.$0.li1 sky130_gnd 0.019646f
Cext_6127 TAIL.$10.li1 sky130_gnd 0.0141508f
Cext_6128 TAIL.$100.li1 VSS.$6.li1 0.00176879f
Cext_6129 TAIL.$100.li1 sky130_gnd 0.0103803f
Cext_6130 TAIL.$102.li1 VSS.$6.li1 0.00176879f
Cext_6131 TAIL.$102.li1 sky130_gnd 0.0103803f
Cext_6132 TAIL.$104.li1 VSS.$6.li1 0.00176879f
Cext_6133 TAIL.$104.li1 sky130_gnd 0.0103803f
Cext_6134 TAIL.$106.li1 VSS.$6.li1 0.00176879f
Cext_6135 TAIL.$106.li1 sky130_gnd 0.0103803f
Cext_6136 TAIL.$108.li1 VSS.$6.li1 0.00176879f
Cext_6137 TAIL.$108.li1 sky130_gnd 0.0103803f
Cext_6138 TAIL.$110.li1 VSS.$6.li1 0.00176879f
Cext_6139 TAIL.$110.li1 sky130_gnd 0.0103803f
Cext_6140 TAIL.$112.li1 VSS.$6.li1 0.00176879f
Cext_6141 TAIL.$112.li1 sky130_gnd 0.0103803f
Cext_6142 TAIL.$114.li1 VSS.$6.li1 0.00176879f
Cext_6143 TAIL.$114.li1 sky130_gnd 0.0103803f
Cext_6144 TAIL.$116.li1 VSS.$6.li1 0.00176879f
Cext_6145 TAIL.$116.li1 sky130_gnd 0.0103803f
Cext_6146 TAIL.$118.li1 VSS.$6.li1 0.00176879f
Cext_6147 TAIL.$118.li1 sky130_gnd 0.0103803f
Cext_6148 TAIL.$12.li1 sky130_gnd 0.0141508f
Cext_6149 TAIL.$120.li1 VSS.$6.li1 0.00176879f
Cext_6150 TAIL.$120.li1 sky130_gnd 0.0103803f
Cext_6151 TAIL.$122.li1 VSS.$6.li1 0.00176879f
Cext_6152 TAIL.$122.li1 sky130_gnd 0.0103803f
Cext_6153 TAIL.$124.li1 VSS.$6.li1 0.00176879f
Cext_6154 TAIL.$124.li1 sky130_gnd 0.0103803f
Cext_6155 TAIL.$126.li1 VSS.$6.li1 0.00176879f
Cext_6156 TAIL.$126.li1 sky130_gnd 0.0103803f
Cext_6157 TAIL.$128.li1 VSS.$415.met3 0.00206477f
Cext_6158 TAIL.$128.li1 VSS.$417.met3 0.00370562f
Cext_6159 TAIL.$128.li1 VSS.$6.li1 0.00176879f
Cext_6160 TAIL.$128.li1 sky130_gnd 0.0103803f
Cext_6161 TAIL.$130.li1 VSS.$417.met3 0.00145449f
Cext_6162 TAIL.$130.li1 VSS.$6.li1 0.00198305f
Cext_6163 TAIL.$130.li1 sky130_gnd 0.00995459f
Cext_6164 TAIL.$132.li1 VSS.$6.li1 0.00207762f
Cext_6165 TAIL.$132.li1 sky130_gnd 0.00995459f
Cext_6166 TAIL.$134.li1 VSS.$6.li1 0.00176879f
Cext_6167 TAIL.$134.li1 sky130_gnd 0.0103803f
Cext_6168 TAIL.$136.li1 VSS.$6.li1 0.00176879f
Cext_6169 TAIL.$136.li1 sky130_gnd 0.0103803f
Cext_6170 TAIL.$138.li1 VSS.$6.li1 0.00176879f
Cext_6171 TAIL.$138.li1 sky130_gnd 0.0103803f
Cext_6172 TAIL.$14.li1 sky130_gnd 0.0141508f
Cext_6173 TAIL.$140.li1 VSS.$6.li1 0.00176879f
Cext_6174 TAIL.$140.li1 sky130_gnd 0.0103803f
Cext_6175 TAIL.$142.li1 VSS.$6.li1 0.00176879f
Cext_6176 TAIL.$142.li1 sky130_gnd 0.0103803f
Cext_6177 TAIL.$144.li1 VSS.$6.li1 0.00176879f
Cext_6178 TAIL.$144.li1 sky130_gnd 0.0103803f
Cext_6179 TAIL.$146.li1 VSS.$6.li1 0.00176879f
Cext_6180 TAIL.$146.li1 sky130_gnd 0.0103803f
Cext_6181 TAIL.$148.li1 VSS.$6.li1 0.00176879f
Cext_6182 TAIL.$148.li1 sky130_gnd 0.0103803f
Cext_6183 TAIL.$150.li1 VSS.$6.li1 0.00176879f
Cext_6184 TAIL.$150.li1 sky130_gnd 0.0103803f
Cext_6185 TAIL.$152.li1 VSS.$6.li1 0.00176879f
Cext_6186 TAIL.$152.li1 sky130_gnd 0.0103803f
Cext_6187 TAIL.$154.li1 VSS.$6.li1 0.00176879f
Cext_6188 TAIL.$154.li1 sky130_gnd 0.0103803f
Cext_6189 TAIL.$156.li1 VSS.$6.li1 0.00176879f
Cext_6190 TAIL.$156.li1 sky130_gnd 0.0103803f
Cext_6191 TAIL.$158.li1 VSS.$6.li1 0.00176879f
Cext_6192 TAIL.$158.li1 sky130_gnd 0.0103803f
Cext_6193 TAIL.$16.li1 sky130_gnd 0.0141508f
Cext_6194 TAIL.$160.li1 VSS.$6.li1 0.00176879f
Cext_6195 TAIL.$160.li1 sky130_gnd 0.0103803f
Cext_6196 TAIL.$162.li1 VSS.$6.li1 0.00176879f
Cext_6197 TAIL.$162.li1 sky130_gnd 0.0103803f
Cext_6198 TAIL.$164.li1 VSS.$6.li1 0.00176879f
Cext_6199 TAIL.$164.li1 sky130_gnd 0.0103803f
Cext_6200 TAIL.$166.li1 VSS.$6.li1 0.00176879f
Cext_6201 TAIL.$166.li1 sky130_gnd 0.0103803f
Cext_6202 TAIL.$168.li1 VSS.$6.li1 0.00176879f
Cext_6203 TAIL.$168.li1 sky130_gnd 0.0103803f
Cext_6204 TAIL.$170.li1 VSS.$6.li1 0.00176879f
Cext_6205 TAIL.$170.li1 sky130_gnd 0.0103803f
Cext_6206 TAIL.$172.li1 VSS.$6.li1 0.00176879f
Cext_6207 TAIL.$172.li1 sky130_gnd 0.0103803f
Cext_6208 TAIL.$174.li1 VSS.$6.li1 0.00169509f
Cext_6209 TAIL.$174.li1 sky130_gnd 0.0163185f
Cext_6210 TAIL.$176.li1 VSS.$14.li1 0.00103015f
Cext_6211 TAIL.$176.li1 VSS.$380.met2 0.00216718f
Cext_6212 TAIL.$176.li1 VSS.$65.li1 0.0134261f
Cext_6213 TAIL.$176.li1 sky130_gnd 0.00671871f
Cext_6214 TAIL.$178.li1 VSS.$16.li1 0.00107494f
Cext_6215 TAIL.$178.li1 VSS.$380.met2 0.00532097f
Cext_6216 TAIL.$178.li1 VSS.$67.li1 0.0139569f
Cext_6217 TAIL.$18.li1 sky130_gnd 0.0141508f
Cext_6218 TAIL.$180.li1 VSS.$18.li1 0.00107494f
Cext_6219 TAIL.$180.li1 VSS.$380.met2 0.00244813f
Cext_6220 TAIL.$180.li1 VSS.$69.li1 0.0139569f
Cext_6221 TAIL.$182.li1 VSS.$20.li1 0.00107494f
Cext_6222 TAIL.$182.li1 VSS.$380.met2 0.00281271f
Cext_6223 TAIL.$182.li1 VSS.$389.met2 0.00113717f
Cext_6224 TAIL.$182.li1 VSS.$62.li1 0.00434906f
Cext_6225 TAIL.$182.li1 VSS.$71.li1 0.00895528f
Cext_6226 TAIL.$184.li1 VSS.$22.li1 0.00107494f
Cext_6227 TAIL.$184.li1 VSS.$380.met2 0.00323495f
Cext_6228 TAIL.$184.li1 VSS.$389.met2 0.0022164f
Cext_6229 TAIL.$184.li1 VSS.$62.li1 0.0133074f
Cext_6230 TAIL.$186.li1 VSS.$24.li1 0.00107494f
Cext_6231 TAIL.$186.li1 VSS.$389.met2 0.00165239f
Cext_6232 TAIL.$186.li1 VSS.$62.li1 0.0133408f
Cext_6233 TAIL.$188.li1 VSS.$26.li1 0.00107494f
Cext_6234 TAIL.$188.li1 VSS.$389.met2 0.00165239f
Cext_6235 TAIL.$188.li1 VSS.$62.li1 0.0133408f
Cext_6236 TAIL.$190.li1 VSS.$28.li1 0.00107494f
Cext_6237 TAIL.$190.li1 VSS.$389.met2 0.00165239f
Cext_6238 TAIL.$190.li1 VSS.$62.li1 0.0133408f
Cext_6239 TAIL.$192.li1 VSS.$30.li1 0.00107494f
Cext_6240 TAIL.$192.li1 VSS.$389.met2 0.00165239f
Cext_6241 TAIL.$192.li1 VSS.$62.li1 0.0133408f
Cext_6242 TAIL.$194.li1 VSS.$32.li1 0.00107494f
Cext_6243 TAIL.$194.li1 VSS.$389.met2 0.00165239f
Cext_6244 TAIL.$194.li1 VSS.$62.li1 0.0133125f
Cext_6245 TAIL.$196.li1 VSS.$34.li1 0.00107494f
Cext_6246 TAIL.$196.li1 VSS.$389.met2 0.00158354f
Cext_6247 TAIL.$196.li1 VSS.$62.li1 0.0133287f
Cext_6248 TAIL.$198.li1 VSS.$36.li1 0.00107494f
Cext_6249 TAIL.$198.li1 VSS.$62.li1 0.0142588f
Cext_6250 TAIL.$2.li1 sky130_gnd 0.0141508f
Cext_6251 TAIL.$20.li1 sky130_gnd 0.0141508f
Cext_6252 TAIL.$200.li1 VSS.$267.met1 0.00165239f
Cext_6253 TAIL.$200.li1 VSS.$38.li1 0.00107494f
Cext_6254 TAIL.$200.li1 VSS.$62.li1 0.0133408f
Cext_6255 TAIL.$202.li1 VSS.$267.met1 0.00165239f
Cext_6256 TAIL.$202.li1 VSS.$40.li1 0.00107494f
Cext_6257 TAIL.$202.li1 VSS.$62.li1 0.0148242f
Cext_6258 TAIL.$204.li1 VSS.$267.met1 0.00165239f
Cext_6259 TAIL.$204.li1 VSS.$42.li1 0.00107494f
Cext_6260 TAIL.$204.li1 VSS.$62.li1 0.0133408f
Cext_6261 TAIL.$206.li1 VSS.$267.met1 0.00165239f
Cext_6262 TAIL.$206.li1 VSS.$44.li1 0.00107494f
Cext_6263 TAIL.$206.li1 VSS.$62.li1 0.0133408f
Cext_6264 TAIL.$208.li1 VSS.$267.met1 0.00165239f
Cext_6265 TAIL.$208.li1 VSS.$46.li1 0.00107494f
Cext_6266 TAIL.$208.li1 VSS.$62.li1 0.0133408f
Cext_6267 TAIL.$210.li1 VSS.$267.met1 0.00165239f
Cext_6268 TAIL.$210.li1 VSS.$48.li1 0.00107494f
Cext_6269 TAIL.$210.li1 VSS.$62.li1 0.0133408f
Cext_6270 TAIL.$212.li1 VSS.$101.li1 0.0106442f
Cext_6271 TAIL.$212.li1 VSS.$50.li1 0.00107494f
Cext_6272 TAIL.$212.li1 VSS.$62.li1 0.00434906f
Cext_6273 TAIL.$214.li1 VSS.$103.li1 0.015751f
Cext_6274 TAIL.$214.li1 VSS.$52.li1 0.00107494f
Cext_6275 TAIL.$216.li1 VSS.$105.li1 0.0157217f
Cext_6276 TAIL.$216.li1 VSS.$54.li1 0.00107494f
Cext_6277 TAIL.$218.li1 VSS.$107.li1 0.0148312f
Cext_6278 TAIL.$218.li1 VSS.$56.li1 0.00103015f
Cext_6279 TAIL.$218.li1 sky130_gnd 0.00671871f
Cext_6280 TAIL.$22.li1 sky130_gnd 0.0141508f
Cext_6281 TAIL.$220.met1 sky130_gnd 0.0259253f
Cext_6282 TAIL.$221.met1 sky130_gnd 0.0191332f
Cext_6283 TAIL.$222.met1 sky130_gnd 0.00300169f
Cext_6284 TAIL.$223.met1 sky130_gnd 0.0144081f
Cext_6285 TAIL.$224.met1 sky130_gnd 0.0144081f
Cext_6286 TAIL.$225.met1 sky130_gnd 0.0144081f
Cext_6287 TAIL.$226.met1 sky130_gnd 0.0144081f
Cext_6288 TAIL.$227.met1 sky130_gnd 0.0144081f
Cext_6289 TAIL.$228.met1 sky130_gnd 0.0144081f
Cext_6290 TAIL.$229.met1 sky130_gnd 0.0144081f
Cext_6291 TAIL.$230.met1 sky130_gnd 0.0144081f
Cext_6292 TAIL.$231.met1 sky130_gnd 0.0144081f
Cext_6293 TAIL.$232.met1 sky130_gnd 0.0144081f
Cext_6294 TAIL.$233.met1 sky130_gnd 0.0144081f
Cext_6295 TAIL.$234.met1 sky130_gnd 0.0144081f
Cext_6296 TAIL.$235.met1 sky130_gnd 0.0144081f
Cext_6297 TAIL.$236.met1 sky130_gnd 0.0144081f
Cext_6298 TAIL.$237.met1 sky130_gnd 0.0144081f
Cext_6299 TAIL.$238.met1 sky130_gnd 0.0144081f
Cext_6300 TAIL.$239.met1 sky130_gnd 0.0144081f
Cext_6301 TAIL.$24.li1 sky130_gnd 0.0141508f
Cext_6302 TAIL.$240.met1 sky130_gnd 0.0144081f
Cext_6303 TAIL.$241.met1 sky130_gnd 0.0144081f
Cext_6304 TAIL.$242.met1 sky130_gnd 0.0144081f
Cext_6305 TAIL.$243.met1 sky130_gnd 0.0144081f
Cext_6306 TAIL.$244.met1 sky130_gnd 0.0144081f
Cext_6307 TAIL.$245.met1 sky130_gnd 0.0144081f
Cext_6308 TAIL.$246.met1 sky130_gnd 0.0144081f
Cext_6309 TAIL.$247.met1 sky130_gnd 0.0144081f
Cext_6310 TAIL.$248.met1 sky130_gnd 0.0144081f
Cext_6311 TAIL.$249.met1 sky130_gnd 0.0144081f
Cext_6312 TAIL.$250.met1 sky130_gnd 0.0144081f
Cext_6313 TAIL.$251.met1 sky130_gnd 0.0144081f
Cext_6314 TAIL.$252.met1 sky130_gnd 0.0144081f
Cext_6315 TAIL.$253.met1 sky130_gnd 0.0144081f
Cext_6316 TAIL.$254.met1 sky130_gnd 0.0144081f
Cext_6317 TAIL.$255.met1 sky130_gnd 0.0144081f
Cext_6318 TAIL.$256.met1 sky130_gnd 0.0144081f
Cext_6319 TAIL.$257.met1 sky130_gnd 0.0144081f
Cext_6320 TAIL.$258.met1 sky130_gnd 0.0144081f
Cext_6321 TAIL.$259.met1 sky130_gnd 0.0144081f
Cext_6322 TAIL.$26.li1 sky130_gnd 0.0141508f
Cext_6323 TAIL.$260.met1 sky130_gnd 0.0144081f
Cext_6324 TAIL.$261.met1 sky130_gnd 0.0144081f
Cext_6325 TAIL.$262.met1 sky130_gnd 0.0144081f
Cext_6326 TAIL.$263.met1 sky130_gnd 0.0144081f
Cext_6327 TAIL.$264.met1 VDD.$344.met1 0.00242546f
Cext_6328 TAIL.$264.met1 sky130_gnd 0.0208253f
Cext_6329 TAIL.$265.met1 sky130_gnd 0.0173146f
Cext_6330 TAIL.$266.met1 sky130_gnd 0.00930211f
Cext_6331 TAIL.$267.met1 sky130_gnd 0.00930211f
Cext_6332 TAIL.$268.met1 sky130_gnd 0.00930211f
Cext_6333 TAIL.$269.met1 sky130_gnd 0.00930211f
Cext_6334 TAIL.$270.met1 sky130_gnd 0.00930211f
Cext_6335 TAIL.$271.met1 sky130_gnd 0.00930211f
Cext_6336 TAIL.$272.met1 sky130_gnd 0.00930211f
Cext_6337 TAIL.$273.met1 sky130_gnd 0.00930211f
Cext_6338 TAIL.$274.met1 sky130_gnd 0.00930211f
Cext_6339 TAIL.$275.met1 sky130_gnd 0.00930211f
Cext_6340 TAIL.$276.met1 sky130_gnd 0.00930211f
Cext_6341 TAIL.$277.met1 VSS.$415.met3 0.0127166f
Cext_6342 TAIL.$277.met1 sky130_gnd 0.00930211f
Cext_6343 TAIL.$278.met1 sky130_gnd 0.00930211f
Cext_6344 TAIL.$279.met1 sky130_gnd 0.00930211f
Cext_6345 TAIL.$28.li1 sky130_gnd 0.0141508f
Cext_6346 TAIL.$280.met1 sky130_gnd 0.00930211f
Cext_6347 TAIL.$281.met1 sky130_gnd 0.00930211f
Cext_6348 TAIL.$282.met1 sky130_gnd 0.00930211f
Cext_6349 TAIL.$283.met1 sky130_gnd 0.00930211f
Cext_6350 TAIL.$284.met1 sky130_gnd 0.00930211f
Cext_6351 TAIL.$285.met1 VSS.$415.met3 0.00835701f
Cext_6352 TAIL.$285.met1 VSS.$417.met3 0.00677335f
Cext_6353 TAIL.$285.met1 sky130_gnd 0.00930211f
Cext_6354 TAIL.$286.met1 VSS.$220.met1 0.00170874f
Cext_6355 TAIL.$286.met1 VSS.$415.met3 0.00412908f
Cext_6356 TAIL.$286.met1 VSS.$417.met3 0.00282731f
Cext_6357 TAIL.$286.met1 sky130_gnd 0.00873659f
Cext_6358 TAIL.$287.met1 VSS.$220.met1 0.0173056f
Cext_6359 TAIL.$287.met1 sky130_gnd 0.00873659f
Cext_6360 TAIL.$288.met1 sky130_gnd 0.00930211f
Cext_6361 TAIL.$289.met1 sky130_gnd 0.00930211f
Cext_6362 TAIL.$290.met1 sky130_gnd 0.00930211f
Cext_6363 TAIL.$291.met1 sky130_gnd 0.00930211f
Cext_6364 TAIL.$292.met1 sky130_gnd 0.00930211f
Cext_6365 TAIL.$293.met1 sky130_gnd 0.00930211f
Cext_6366 TAIL.$294.met1 sky130_gnd 0.00930211f
Cext_6367 TAIL.$295.met1 sky130_gnd 0.00930211f
Cext_6368 TAIL.$296.met1 sky130_gnd 0.00930211f
Cext_6369 TAIL.$297.met1 VSS.$415.met3 0.0145871f
Cext_6370 TAIL.$297.met1 sky130_gnd 0.00930211f
Cext_6371 TAIL.$298.met1 sky130_gnd 0.00930211f
Cext_6372 TAIL.$299.met1 sky130_gnd 0.00930211f
Cext_6373 TAIL.$30.li1 sky130_gnd 0.0141508f
Cext_6374 TAIL.$300.met1 sky130_gnd 0.00930211f
Cext_6375 TAIL.$301.met1 sky130_gnd 0.00930211f
Cext_6376 TAIL.$302.met1 sky130_gnd 0.00930211f
Cext_6377 TAIL.$303.met1 sky130_gnd 0.00930211f
Cext_6378 TAIL.$304.met1 sky130_gnd 0.00930211f
Cext_6379 TAIL.$305.met1 sky130_gnd 0.00930211f
Cext_6380 TAIL.$306.met1 sky130_gnd 0.00930211f
Cext_6381 TAIL.$307.met1 sky130_gnd 0.00930211f
Cext_6382 TAIL.$308.met1 sky130_gnd 0.0168846f
Cext_6383 TAIL.$309.met1 sky130_gnd 0.00120071f
Cext_6384 TAIL.$310.met1 VSS.$258.met1 0.00212499f
Cext_6385 TAIL.$310.met1 VSS.$380.met2 0.00555024f
Cext_6386 TAIL.$310.met1 sky130_gnd 0.00119546f
Cext_6387 TAIL.$311.met1 VSS.$236.met1 0.0015475f
Cext_6388 TAIL.$311.met1 VSS.$274.met1 0.00221365f
Cext_6389 TAIL.$311.met1 VSS.$380.met2 0.00156725f
Cext_6390 TAIL.$311.met1 VSS.$65.li1 0.00407332f
Cext_6391 TAIL.$311.met1 sky130_gnd 0.0160735f
Cext_6392 TAIL.$312.met1 VSS.$269.met1 0.00275293f
Cext_6393 TAIL.$312.met1 VSS.$380.met2 0.00267362f
Cext_6394 TAIL.$312.met1 VSS.$67.li1 0.00537387f
Cext_6395 TAIL.$312.met1 sky130_gnd 0.00755113f
Cext_6396 TAIL.$313.met1 VSS.$238.met1 0.00175381f
Cext_6397 TAIL.$313.met1 VSS.$276.met1 0.00250875f
Cext_6398 TAIL.$313.met1 VSS.$380.met2 0.0125353f
Cext_6399 TAIL.$313.met1 VSS.$392.met2 0.00107568f
Cext_6400 TAIL.$313.met1 VSS.$69.li1 0.00446555f
Cext_6401 TAIL.$313.met1 sky130_gnd 0.00776772f
Cext_6402 TAIL.$314.met1 VSS.$239.met1 0.00183333f
Cext_6403 TAIL.$314.met1 VSS.$277.met1 0.00262252f
Cext_6404 TAIL.$314.met1 VSS.$380.met2 0.0101282f
Cext_6405 TAIL.$314.met1 VSS.$389.met2 0.00502934f
Cext_6406 TAIL.$314.met1 VSS.$392.met2 0.00190746f
Cext_6407 TAIL.$314.met1 VSS.$71.li1 0.00372385f
Cext_6408 TAIL.$314.met1 sky130_gnd 0.00776772f
Cext_6409 TAIL.$315.met1 VSS.$240.met1 0.00183333f
Cext_6410 TAIL.$315.met1 VSS.$278.met1 0.00262252f
Cext_6411 TAIL.$315.met1 VSS.$380.met2 0.0120992f
Cext_6412 TAIL.$315.met1 VSS.$389.met2 0.0227742f
Cext_6413 TAIL.$315.met1 VSS.$62.li1 0.00446555f
Cext_6414 TAIL.$315.met1 sky130_gnd 0.00776772f
Cext_6415 TAIL.$316.met1 VSS.$241.met1 0.00183333f
Cext_6416 TAIL.$316.met1 VSS.$279.met1 0.00262252f
Cext_6417 TAIL.$316.met1 VSS.$389.met2 0.00757993f
Cext_6418 TAIL.$316.met1 VSS.$62.li1 0.00453152f
Cext_6419 TAIL.$316.met1 sky130_gnd 0.00776772f
Cext_6420 TAIL.$317.met1 VSS.$242.met1 0.00183333f
Cext_6421 TAIL.$317.met1 VSS.$280.met1 0.00262252f
Cext_6422 TAIL.$317.met1 VSS.$389.met2 0.00757993f
Cext_6423 TAIL.$317.met1 VSS.$62.li1 0.00453152f
Cext_6424 TAIL.$317.met1 sky130_gnd 0.00776772f
Cext_6425 TAIL.$318.met1 VSS.$243.met1 0.00183333f
Cext_6426 TAIL.$318.met1 VSS.$281.met1 0.00262252f
Cext_6427 TAIL.$318.met1 VSS.$389.met2 0.00757993f
Cext_6428 TAIL.$318.met1 VSS.$62.li1 0.00453152f
Cext_6429 TAIL.$318.met1 sky130_gnd 0.00776772f
Cext_6430 TAIL.$319.met1 VSS.$244.met1 0.00183333f
Cext_6431 TAIL.$319.met1 VSS.$282.met1 0.00262252f
Cext_6432 TAIL.$319.met1 VSS.$389.met2 0.00757993f
Cext_6433 TAIL.$319.met1 VSS.$62.li1 0.00453152f
Cext_6434 TAIL.$319.met1 sky130_gnd 0.00776772f
Cext_6435 TAIL.$32.li1 sky130_gnd 0.0141508f
Cext_6436 TAIL.$320.met1 VSS.$245.met1 0.00183333f
Cext_6437 TAIL.$320.met1 VSS.$283.met1 0.00262252f
Cext_6438 TAIL.$320.met1 VSS.$389.met2 0.00789673f
Cext_6439 TAIL.$320.met1 VSS.$390.met2 0.00179924f
Cext_6440 TAIL.$320.met1 VSS.$62.li1 0.00453152f
Cext_6441 TAIL.$320.met1 sky130_gnd 0.00776772f
Cext_6442 TAIL.$321.met1 VSS.$246.met1 0.00183333f
Cext_6443 TAIL.$321.met1 VSS.$267.met1 0.00395506f
Cext_6444 TAIL.$321.met1 VSS.$284.met1 0.00145695f
Cext_6445 TAIL.$321.met1 VSS.$389.met2 0.00513412f
Cext_6446 TAIL.$321.met1 VSS.$390.met2 0.00208008f
Cext_6447 TAIL.$321.met1 VSS.$62.li1 0.00627914f
Cext_6448 TAIL.$321.met1 sky130_gnd 0.0043154f
Cext_6449 TAIL.$322.met1 VSS.$247.met1 0.00183333f
Cext_6450 TAIL.$322.met1 VSS.$267.met1 0.00507876f
Cext_6451 TAIL.$322.met1 VSS.$285.met1 0.00145695f
Cext_6452 TAIL.$322.met1 VSS.$390.met2 0.00227248f
Cext_6453 TAIL.$322.met1 VSS.$62.li1 0.00628956f
Cext_6454 TAIL.$322.met1 sky130_gnd 0.0043154f
Cext_6455 TAIL.$323.met1 VREF.$100.met2 0.00537014f
Cext_6456 TAIL.$323.met1 VREF.$107.met3 0.00683091f
Cext_6457 TAIL.$323.met1 VSS.$248.met1 0.00183333f
Cext_6458 TAIL.$323.met1 VSS.$267.met1 0.00202267f
Cext_6459 TAIL.$323.met1 VSS.$286.met1 0.00262252f
Cext_6460 TAIL.$323.met1 VSS.$62.li1 0.00456279f
Cext_6461 TAIL.$323.met1 sky130_gnd 0.00776772f
Cext_6462 TAIL.$324.met1 VREF.$100.met2 0.00537014f
Cext_6463 TAIL.$324.met1 VREF.$107.met3 0.00105365f
Cext_6464 TAIL.$324.met1 VSS.$249.met1 0.00183333f
Cext_6465 TAIL.$324.met1 VSS.$267.met1 0.00202267f
Cext_6466 TAIL.$324.met1 VSS.$287.met1 0.00262252f
Cext_6467 TAIL.$324.met1 VSS.$389.met2 0.0153857f
Cext_6468 TAIL.$324.met1 VSS.$62.li1 0.00453152f
Cext_6469 TAIL.$324.met1 sky130_gnd 0.00776772f
Cext_6470 TAIL.$325.met1 VREF.$100.met2 0.00537014f
Cext_6471 TAIL.$325.met1 VSS.$250.met1 0.00183333f
Cext_6472 TAIL.$325.met1 VSS.$267.met1 0.00202267f
Cext_6473 TAIL.$325.met1 VSS.$288.met1 0.00262252f
Cext_6474 TAIL.$325.met1 VSS.$62.li1 0.00466028f
Cext_6475 TAIL.$325.met1 sky130_gnd 0.00776772f
Cext_6476 TAIL.$326.met1 VREF.$100.met2 0.00537014f
Cext_6477 TAIL.$326.met1 VSS.$251.met1 0.00183333f
Cext_6478 TAIL.$326.met1 VSS.$267.met1 0.00202267f
Cext_6479 TAIL.$326.met1 VSS.$289.met1 0.00262252f
Cext_6480 TAIL.$326.met1 VSS.$62.li1 0.00466028f
Cext_6481 TAIL.$326.met1 sky130_gnd 0.00776772f
Cext_6482 TAIL.$327.met1 VREF.$100.met2 0.00537014f
Cext_6483 TAIL.$327.met1 VSS.$252.met1 0.00183333f
Cext_6484 TAIL.$327.met1 VSS.$267.met1 0.00202267f
Cext_6485 TAIL.$327.met1 VSS.$290.met1 0.00262252f
Cext_6486 TAIL.$327.met1 VSS.$62.li1 0.00466028f
Cext_6487 TAIL.$327.met1 sky130_gnd 0.00776772f
Cext_6488 TAIL.$328.met1 VREF.$100.met2 0.00537014f
Cext_6489 TAIL.$328.met1 VSS.$253.met1 0.00183333f
Cext_6490 TAIL.$328.met1 VSS.$267.met1 0.00181102f
Cext_6491 TAIL.$328.met1 VSS.$291.met1 0.00262252f
Cext_6492 TAIL.$328.met1 VSS.$62.li1 0.00487194f
Cext_6493 TAIL.$328.met1 sky130_gnd 0.00776772f
Cext_6494 TAIL.$329.met1 VREF.$100.met2 0.00537014f
Cext_6495 TAIL.$329.met1 VSS.$101.li1 0.00594126f
Cext_6496 TAIL.$329.met1 VSS.$254.met1 0.00183333f
Cext_6497 TAIL.$329.met1 VSS.$292.met1 0.00262252f
Cext_6498 TAIL.$329.met1 sky130_gnd 0.00776772f
Cext_6499 TAIL.$330.met1 VREF.$100.met2 0.00537014f
Cext_6500 TAIL.$330.met1 VSS.$103.li1 0.00668296f
Cext_6501 TAIL.$330.met1 VSS.$255.met1 0.00183333f
Cext_6502 TAIL.$330.met1 VSS.$293.met1 0.00262252f
Cext_6503 TAIL.$330.met1 sky130_gnd 0.00776772f
Cext_6504 TAIL.$331.met1 VREF.$100.met2 0.00537014f
Cext_6505 TAIL.$331.met1 VSS.$105.li1 0.0065612f
Cext_6506 TAIL.$331.met1 VSS.$256.met1 0.00183333f
Cext_6507 TAIL.$331.met1 VSS.$294.met1 0.00262252f
Cext_6508 TAIL.$331.met1 sky130_gnd 0.00776772f
Cext_6509 TAIL.$332.met1 VREF.$100.met2 0.00484804f
Cext_6510 TAIL.$332.met1 VSS.$107.li1 0.00575299f
Cext_6511 TAIL.$332.met1 VSS.$257.met1 0.00165509f
Cext_6512 TAIL.$332.met1 VSS.$295.met1 0.00236755f
Cext_6513 TAIL.$332.met1 sky130_gnd 0.0160735f
Cext_6514 TAIL.$333.met2 sky130_gnd 0.028988f
Cext_6515 TAIL.$334.met2 sky130_gnd 0.0025272f
Cext_6516 TAIL.$335.met2 sky130_gnd 0.00130812f
Cext_6517 TAIL.$338.met2 VSS.$380.met2 0.0085368f
Cext_6518 TAIL.$338.met2 VSS.$392.met2 0.00509135f
Cext_6519 TAIL.$338.met2 VSS.$67.li1 0.00144327f
Cext_6520 TAIL.$338.met2 sky130_gnd 0.0130388f
Cext_6521 TAIL.$339.met3 sky130_gnd 0.0459968f
Cext_6522 TAIL.$34.li1 sky130_gnd 0.0141508f
Cext_6523 TAIL.$340.met3 VSS.$14.li1 0.00138219f
Cext_6524 TAIL.$340.met3 VSS.$16.li1 0.00172607f
Cext_6525 TAIL.$340.met3 VSS.$18.li1 0.00315483f
Cext_6526 TAIL.$340.met3 VSS.$237.met1 0.0072886f
Cext_6527 TAIL.$340.met3 VSS.$366.met2 0.0165219f
Cext_6528 TAIL.$340.met3 VSS.$379.met2 0.0177407f
Cext_6529 TAIL.$340.met3 VSS.$6.li1 0.00371272f
Cext_6530 TAIL.$340.met3 sky130_gnd 0.178331f
Cext_6531 TAIL.$341.met3 VSS.$16.li1 0.00697502f
Cext_6532 TAIL.$341.met3 VSS.$236.met1 0.00250756f
Cext_6533 TAIL.$341.met3 VSS.$378.met2 0.0386224f
Cext_6534 TAIL.$341.met3 VSS.$379.met2 0.0250292f
Cext_6535 TAIL.$341.met3 VSS.$380.met2 0.131888f
Cext_6536 TAIL.$341.met3 VSS.$422.met3 0.00921254f
Cext_6537 TAIL.$341.met3 sky130_gnd 0.0533447f
Cext_6538 TAIL.$36.li1 sky130_gnd 0.0141508f
Cext_6539 TAIL.$38.li1 sky130_gnd 0.0141508f
Cext_6540 TAIL.$4.li1 sky130_gnd 0.0141508f
Cext_6541 TAIL.$40.li1 sky130_gnd 0.0141508f
Cext_6542 TAIL.$42.li1 sky130_gnd 0.0141508f
Cext_6543 TAIL.$44.li1 sky130_gnd 0.0141508f
Cext_6544 TAIL.$46.li1 sky130_gnd 0.0141508f
Cext_6545 TAIL.$48.li1 sky130_gnd 0.0141508f
Cext_6546 TAIL.$50.li1 sky130_gnd 0.0141508f
Cext_6547 TAIL.$52.li1 sky130_gnd 0.0141508f
Cext_6548 TAIL.$54.li1 sky130_gnd 0.0141508f
Cext_6549 TAIL.$56.li1 sky130_gnd 0.0141508f
Cext_6550 TAIL.$58.li1 sky130_gnd 0.0141508f
Cext_6551 TAIL.$6.li1 sky130_gnd 0.0141508f
Cext_6552 TAIL.$60.li1 sky130_gnd 0.0141508f
Cext_6553 TAIL.$62.li1 sky130_gnd 0.0141508f
Cext_6554 TAIL.$64.li1 sky130_gnd 0.0141508f
Cext_6555 TAIL.$66.li1 sky130_gnd 0.0141508f
Cext_6556 TAIL.$68.li1 sky130_gnd 0.0141508f
Cext_6557 TAIL.$70.li1 sky130_gnd 0.0141508f
Cext_6558 TAIL.$72.li1 sky130_gnd 0.0141508f
Cext_6559 TAIL.$74.li1 sky130_gnd 0.0141508f
Cext_6560 TAIL.$76.li1 sky130_gnd 0.0141508f
Cext_6561 TAIL.$78.li1 sky130_gnd 0.0141508f
Cext_6562 TAIL.$8.li1 sky130_gnd 0.0141508f
Cext_6563 TAIL.$80.li1 sky130_gnd 0.0141508f
Cext_6564 TAIL.$82.li1 sky130_gnd 0.0141508f
Cext_6565 TAIL.$84.li1 sky130_gnd 0.0141508f
Cext_6566 TAIL.$86.li1 sky130_gnd 0.0195605f
Cext_6567 TAIL.$88.li1 VSS.$6.li1 0.00169509f
Cext_6568 TAIL.$88.li1 sky130_gnd 0.016521f
Cext_6569 TAIL.$90.li1 VSS.$6.li1 0.00176879f
Cext_6570 TAIL.$90.li1 sky130_gnd 0.0103803f
Cext_6571 TAIL.$92.li1 VSS.$6.li1 0.00176879f
Cext_6572 TAIL.$92.li1 sky130_gnd 0.0103803f
Cext_6573 TAIL.$94.li1 VSS.$6.li1 0.00176879f
Cext_6574 TAIL.$94.li1 sky130_gnd 0.0103803f
Cext_6575 TAIL.$96.li1 VSS.$6.li1 0.00176879f
Cext_6576 TAIL.$96.li1 sky130_gnd 0.0103803f
Cext_6577 TAIL.$98.li1 VSS.$6.li1 0.00176879f
Cext_6578 TAIL.$98.li1 sky130_gnd 0.0103803f
Cext_6579 TAIL.P0.nsdm VREF.$100.met2 0.00301763f
Cext_6580 TAIL.P0.nsdm VSS.$380.met2 0.00125388f
Cext_6581 TAIL.P0.nsdm VSS.$389.met2 0.0050153f
Cext_6582 TAIL.P0.nsdm VSS.$62.li1 0.0145072f
Cext_6583 TAIL.P2.nsdm VSS.$415.met3 0.00650034f
Cext_6584 TAIL.P2.nsdm VSS.$6.li1 0.0107282f
Cext_6585 VDD.$0.li1 sky130_gnd 0.0152309f
Cext_6586 VDD.$10.li1 sky130_gnd 0.011863f
Cext_6587 VDD.$100.li1 sky130_gnd 0.0081986f
Cext_6588 VDD.$102.li1 sky130_gnd 0.0081986f
Cext_6589 VDD.$104.li1 sky130_gnd 0.0081986f
Cext_6590 VDD.$106.li1 sky130_gnd 0.0081986f
Cext_6591 VDD.$108.li1 sky130_gnd 0.0081986f
Cext_6592 VDD.$110.li1 sky130_gnd 0.0122096f
Cext_6593 VDD.$112.li1 sky130_gnd 0.0119831f
Cext_6594 VDD.$113.li1 sky130_gnd 0.00796218f
Cext_6595 VDD.$114.li1 sky130_gnd 0.00796218f
Cext_6596 VDD.$115.li1 sky130_gnd 0.00796218f
Cext_6597 VDD.$116.li1 sky130_gnd 0.00796218f
Cext_6598 VDD.$117.li1 sky130_gnd 0.00796218f
Cext_6599 VDD.$118.li1 sky130_gnd 0.00796218f
Cext_6600 VDD.$119.li1 sky130_gnd 0.00796218f
Cext_6601 VDD.$12.li1 sky130_gnd 0.011863f
Cext_6602 VDD.$120.li1 sky130_gnd 0.00796218f
Cext_6603 VDD.$121.li1 sky130_gnd 0.00796218f
Cext_6604 VDD.$122.li1 sky130_gnd 0.00496031f
Cext_6605 VDD.$123.li1 sky130_gnd 0.00496031f
Cext_6606 VDD.$124.li1 sky130_gnd 0.00796218f
Cext_6607 VDD.$125.li1 sky130_gnd 0.00796218f
Cext_6608 VDD.$126.li1 sky130_gnd 0.00796218f
Cext_6609 VDD.$127.li1 sky130_gnd 0.00796218f
Cext_6610 VDD.$128.li1 sky130_gnd 0.00796218f
Cext_6611 VDD.$129.li1 sky130_gnd 0.00796218f
Cext_6612 VDD.$130.li1 sky130_gnd 0.00796218f
Cext_6613 VDD.$131.li1 sky130_gnd 0.00796218f
Cext_6614 VDD.$132.li1 sky130_gnd 0.00796218f
Cext_6615 VDD.$133.li1 sky130_gnd 0.0119831f
Cext_6616 VDD.$134.li1 sky130_gnd 0.00106807f
Cext_6617 VDD.$135.li1 sky130_gnd 0.0261754f
Cext_6618 VDD.$136.li1 VREF.$0.li1 0.00103015f
Cext_6619 VDD.$136.li1 sky130_gnd 0.0122096f
Cext_6620 VDD.$138.li1 VREF.$2.li1 0.00107494f
Cext_6621 VDD.$138.li1 sky130_gnd 0.0081986f
Cext_6622 VDD.$14.li1 sky130_gnd 0.011863f
Cext_6623 VDD.$140.li1 VREF.$4.li1 0.00107494f
Cext_6624 VDD.$140.li1 sky130_gnd 0.0081986f
Cext_6625 VDD.$142.li1 VREF.$6.li1 0.00107494f
Cext_6626 VDD.$142.li1 sky130_gnd 0.0081986f
Cext_6627 VDD.$144.li1 VREF.$8.li1 0.00107494f
Cext_6628 VDD.$144.li1 sky130_gnd 0.0081986f
Cext_6629 VDD.$146.li1 VREF.$10.li1 0.00107494f
Cext_6630 VDD.$146.li1 sky130_gnd 0.0081986f
Cext_6631 VDD.$148.li1 VREF.$12.li1 0.00107494f
Cext_6632 VDD.$148.li1 sky130_gnd 0.0081986f
Cext_6633 VDD.$150.li1 VREF.$14.li1 0.00107494f
Cext_6634 VDD.$150.li1 sky130_gnd 0.0081986f
Cext_6635 VDD.$152.li1 VREF.$16.li1 0.00107494f
Cext_6636 VDD.$152.li1 sky130_gnd 0.0081986f
Cext_6637 VDD.$154.li1 VREF.$18.li1 0.00107494f
Cext_6638 VDD.$154.li1 sky130_gnd 0.0081986f
Cext_6639 VDD.$156.li1 VREF.$20.li1 0.00107494f
Cext_6640 VDD.$156.li1 sky130_gnd 0.00804856f
Cext_6641 VDD.$158.li1 VREF.$22.li1 0.00107494f
Cext_6642 VDD.$158.li1 sky130_gnd 0.00804856f
Cext_6643 VDD.$16.li1 sky130_gnd 0.011863f
Cext_6644 VDD.$160.li1 VREF.$24.li1 0.00107494f
Cext_6645 VDD.$160.li1 sky130_gnd 0.0081986f
Cext_6646 VDD.$162.li1 VREF.$26.li1 0.00107494f
Cext_6647 VDD.$162.li1 sky130_gnd 0.0081986f
Cext_6648 VDD.$164.li1 VREF.$28.li1 0.00107494f
Cext_6649 VDD.$164.li1 sky130_gnd 0.0081986f
Cext_6650 VDD.$166.li1 VREF.$30.li1 0.00107494f
Cext_6651 VDD.$166.li1 sky130_gnd 0.0081986f
Cext_6652 VDD.$168.li1 VREF.$32.li1 0.00107494f
Cext_6653 VDD.$168.li1 sky130_gnd 0.0081986f
Cext_6654 VDD.$170.li1 VREF.$34.li1 0.00107494f
Cext_6655 VDD.$170.li1 sky130_gnd 0.0081986f
Cext_6656 VDD.$172.li1 VREF.$36.li1 0.00107494f
Cext_6657 VDD.$172.li1 sky130_gnd 0.0081986f
Cext_6658 VDD.$174.li1 VREF.$38.li1 0.00107494f
Cext_6659 VDD.$174.li1 sky130_gnd 0.0081986f
Cext_6660 VDD.$176.li1 VREF.$40.li1 0.00107494f
Cext_6661 VDD.$176.li1 sky130_gnd 0.0081986f
Cext_6662 VDD.$178.li1 VREF.$42.li1 0.00103015f
Cext_6663 VDD.$178.li1 sky130_gnd 0.0122096f
Cext_6664 VDD.$18.li1 sky130_gnd 0.011863f
Cext_6665 VDD.$180.li1 VREF.$0.li1 0.0157119f
Cext_6666 VDD.$180.li1 VREF.$101.met2 0.00257108f
Cext_6667 VDD.$180.li1 VREF.$63.met1 0.00126132f
Cext_6668 VDD.$180.li1 VREF.$85.met1 0.00674196f
Cext_6669 VDD.$180.li1 sky130_gnd 0.0119831f
Cext_6670 VDD.$181.li1 VREF.$2.li1 0.0176585f
Cext_6671 VDD.$181.li1 VREF.$64.met1 0.00615293f
Cext_6672 VDD.$181.li1 sky130_gnd 0.00796218f
Cext_6673 VDD.$182.li1 VREF.$4.li1 0.0171345f
Cext_6674 VDD.$182.li1 VREF.$65.met1 0.00679352f
Cext_6675 VDD.$182.li1 sky130_gnd 0.00796218f
Cext_6676 VDD.$183.li1 VREF.$6.li1 0.0168203f
Cext_6677 VDD.$183.li1 VREF.$66.met1 0.00639308f
Cext_6678 VDD.$183.li1 sky130_gnd 0.00796218f
Cext_6679 VDD.$184.li1 VREF.$67.met1 0.0068187f
Cext_6680 VDD.$184.li1 VREF.$8.li1 0.0171639f
Cext_6681 VDD.$184.li1 sky130_gnd 0.00796218f
Cext_6682 VDD.$185.li1 VREF.$10.li1 0.0168567f
Cext_6683 VDD.$185.li1 VREF.$68.met1 0.00698372f
Cext_6684 VDD.$185.li1 sky130_gnd 0.00796218f
Cext_6685 VDD.$186.li1 VREF.$12.li1 0.0168567f
Cext_6686 VDD.$186.li1 VREF.$69.met1 0.00702021f
Cext_6687 VDD.$186.li1 sky130_gnd 0.00796218f
Cext_6688 VDD.$187.li1 VREF.$14.li1 0.0168567f
Cext_6689 VDD.$187.li1 VREF.$70.met1 0.00702021f
Cext_6690 VDD.$187.li1 sky130_gnd 0.00796218f
Cext_6691 VDD.$188.li1 VREF.$16.li1 0.0168567f
Cext_6692 VDD.$188.li1 VREF.$71.met1 0.00745982f
Cext_6693 VDD.$188.li1 sky130_gnd 0.00796218f
Cext_6694 VDD.$189.li1 VREF.$18.li1 0.0168567f
Cext_6695 VDD.$189.li1 VREF.$72.met1 0.0075578f
Cext_6696 VDD.$189.li1 sky130_gnd 0.00796218f
Cext_6697 VDD.$190.li1 VREF.$20.li1 0.0153548f
Cext_6698 VDD.$190.li1 VREF.$73.met1 0.00536589f
Cext_6699 VDD.$190.li1 sky130_gnd 0.00501249f
Cext_6700 VDD.$191.li1 VREF.$101.met2 0.00370264f
Cext_6701 VDD.$191.li1 VREF.$22.li1 0.0153322f
Cext_6702 VDD.$191.li1 VREF.$74.met1 0.00429011f
Cext_6703 VDD.$191.li1 VREF.$85.met1 0.00192507f
Cext_6704 VDD.$191.li1 sky130_gnd 0.00501249f
Cext_6705 VDD.$192.li1 VREF.$24.li1 0.0167389f
Cext_6706 VDD.$192.li1 VREF.$75.met1 0.00702819f
Cext_6707 VDD.$192.li1 sky130_gnd 0.00796218f
Cext_6708 VDD.$193.li1 VREF.$26.li1 0.0166794f
Cext_6709 VDD.$193.li1 VREF.$76.met1 0.00639308f
Cext_6710 VDD.$193.li1 sky130_gnd 0.00796218f
Cext_6711 VDD.$194.li1 VREF.$28.li1 0.0166794f
Cext_6712 VDD.$194.li1 VREF.$77.met1 0.00647487f
Cext_6713 VDD.$194.li1 sky130_gnd 0.00796218f
Cext_6714 VDD.$195.li1 VREF.$30.li1 0.0166794f
Cext_6715 VDD.$195.li1 VREF.$78.met1 0.00647487f
Cext_6716 VDD.$195.li1 sky130_gnd 0.00796218f
Cext_6717 VDD.$196.li1 VREF.$32.li1 0.0166794f
Cext_6718 VDD.$196.li1 VREF.$79.met1 0.00647487f
Cext_6719 VDD.$196.li1 sky130_gnd 0.00796218f
Cext_6720 VDD.$197.li1 VREF.$34.li1 0.0166794f
Cext_6721 VDD.$197.li1 VREF.$80.met1 0.00647487f
Cext_6722 VDD.$197.li1 sky130_gnd 0.00796218f
Cext_6723 VDD.$198.li1 VREF.$36.li1 0.0166794f
Cext_6724 VDD.$198.li1 VREF.$81.met1 0.00647487f
Cext_6725 VDD.$198.li1 sky130_gnd 0.00796218f
Cext_6726 VDD.$199.li1 VREF.$38.li1 0.0166794f
Cext_6727 VDD.$199.li1 VREF.$82.met1 0.00647487f
Cext_6728 VDD.$199.li1 sky130_gnd 0.00796218f
Cext_6729 VDD.$2.li1 sky130_gnd 0.011863f
Cext_6730 VDD.$20.li1 sky130_gnd 0.011863f
Cext_6731 VDD.$200.li1 VREF.$40.li1 0.0166794f
Cext_6732 VDD.$200.li1 VREF.$83.met1 0.00647487f
Cext_6733 VDD.$200.li1 sky130_gnd 0.00796218f
Cext_6734 VDD.$201.li1 VREF.$42.li1 0.0158673f
Cext_6735 VDD.$201.li1 VREF.$84.met1 0.00584537f
Cext_6736 VDD.$201.li1 sky130_gnd 0.0119831f
Cext_6737 VDD.$202.li1 VREF.$20.li1 0.0012197f
Cext_6738 VDD.$202.li1 VREF.$22.li1 0.0012197f
Cext_6739 VDD.$202.li1 VREF.$73.met1 0.0034867f
Cext_6740 VDD.$202.li1 VREF.$74.met1 0.0034867f
Cext_6741 VDD.$202.li1 sky130_gnd 0.00106807f
Cext_6742 VDD.$203.li1 sky130_gnd 0.0261754f
Cext_6743 VDD.$204.li1 sky130_gnd 0.0122096f
Cext_6744 VDD.$206.li1 sky130_gnd 0.0081986f
Cext_6745 VDD.$208.li1 sky130_gnd 0.0081986f
Cext_6746 VDD.$210.li1 sky130_gnd 0.0081986f
Cext_6747 VDD.$212.li1 sky130_gnd 0.0081986f
Cext_6748 VDD.$214.li1 sky130_gnd 0.0081986f
Cext_6749 VDD.$216.li1 sky130_gnd 0.0081986f
Cext_6750 VDD.$218.li1 sky130_gnd 0.0081986f
Cext_6751 VDD.$22.li1 sky130_gnd 0.011863f
Cext_6752 VDD.$220.li1 sky130_gnd 0.0081986f
Cext_6753 VDD.$222.li1 sky130_gnd 0.0081986f
Cext_6754 VDD.$224.li1 sky130_gnd 0.00804856f
Cext_6755 VDD.$226.li1 sky130_gnd 0.00804856f
Cext_6756 VDD.$228.li1 sky130_gnd 0.0081986f
Cext_6757 VDD.$230.li1 sky130_gnd 0.0081986f
Cext_6758 VDD.$232.li1 sky130_gnd 0.0081986f
Cext_6759 VDD.$234.li1 sky130_gnd 0.0081986f
Cext_6760 VDD.$236.li1 sky130_gnd 0.0081986f
Cext_6761 VDD.$238.li1 sky130_gnd 0.0081986f
Cext_6762 VDD.$24.li1 sky130_gnd 0.011863f
Cext_6763 VDD.$240.li1 sky130_gnd 0.0081986f
Cext_6764 VDD.$242.li1 sky130_gnd 0.0081986f
Cext_6765 VDD.$244.li1 sky130_gnd 0.0081986f
Cext_6766 VDD.$246.li1 sky130_gnd 0.0122096f
Cext_6767 VDD.$248.li1 sky130_gnd 0.0119831f
Cext_6768 VDD.$249.li1 sky130_gnd 0.00796218f
Cext_6769 VDD.$250.li1 sky130_gnd 0.00796218f
Cext_6770 VDD.$251.li1 sky130_gnd 0.00796218f
Cext_6771 VDD.$252.li1 sky130_gnd 0.00796218f
Cext_6772 VDD.$253.li1 sky130_gnd 0.00796218f
Cext_6773 VDD.$254.li1 sky130_gnd 0.00796218f
Cext_6774 VDD.$255.li1 sky130_gnd 0.00796218f
Cext_6775 VDD.$256.li1 sky130_gnd 0.00796218f
Cext_6776 VDD.$257.li1 sky130_gnd 0.00796218f
Cext_6777 VDD.$258.li1 sky130_gnd 0.00501249f
Cext_6778 VDD.$259.li1 sky130_gnd 0.00501249f
Cext_6779 VDD.$26.li1 sky130_gnd 0.011863f
Cext_6780 VDD.$260.li1 sky130_gnd 0.00796218f
Cext_6781 VDD.$261.li1 sky130_gnd 0.0115425f
Cext_6782 VDD.$262.li1 sky130_gnd 0.0115425f
Cext_6783 VDD.$263.li1 sky130_gnd 0.0115425f
Cext_6784 VDD.$264.li1 sky130_gnd 0.0115425f
Cext_6785 VDD.$265.li1 sky130_gnd 0.0115425f
Cext_6786 VDD.$266.li1 sky130_gnd 0.0115425f
Cext_6787 VDD.$267.li1 sky130_gnd 0.0115425f
Cext_6788 VDD.$268.li1 sky130_gnd 0.0115425f
Cext_6789 VDD.$269.li1 sky130_gnd 0.0154142f
Cext_6790 VDD.$270.li1 sky130_gnd 0.00106807f
Cext_6791 VDD.$271.li1 sky130_gnd 0.0261754f
Cext_6792 VDD.$272.li1 sky130_gnd 0.0122649f
Cext_6793 VDD.$274.li1 sky130_gnd 0.0081986f
Cext_6794 VDD.$276.li1 sky130_gnd 0.0081986f
Cext_6795 VDD.$278.li1 sky130_gnd 0.0081986f
Cext_6796 VDD.$28.li1 sky130_gnd 0.011863f
Cext_6797 VDD.$280.li1 sky130_gnd 0.0081986f
Cext_6798 VDD.$282.li1 sky130_gnd 0.0081986f
Cext_6799 VDD.$284.li1 sky130_gnd 0.0081986f
Cext_6800 VDD.$286.li1 sky130_gnd 0.0081986f
Cext_6801 VDD.$288.li1 sky130_gnd 0.0081986f
Cext_6802 VDD.$290.li1 sky130_gnd 0.0081986f
Cext_6803 VDD.$292.li1 sky130_gnd 0.012151f
Cext_6804 VDD.$294.li1 sky130_gnd 0.0120383f
Cext_6805 VDD.$295.li1 sky130_gnd 0.00796218f
Cext_6806 VDD.$296.li1 sky130_gnd 0.00796218f
Cext_6807 VDD.$297.li1 sky130_gnd 0.00796218f
Cext_6808 VDD.$298.li1 sky130_gnd 0.00796218f
Cext_6809 VDD.$299.li1 sky130_gnd 0.00493957f
Cext_6810 VDD.$30.li1 sky130_gnd 0.011863f
Cext_6811 VDD.$300.li1 sky130_gnd 0.00796218f
Cext_6812 VDD.$301.li1 sky130_gnd 0.00796218f
Cext_6813 VDD.$302.li1 sky130_gnd 0.00796218f
Cext_6814 VDD.$303.li1 sky130_gnd 0.00796218f
Cext_6815 VDD.$304.li1 sky130_gnd 0.0120383f
Cext_6816 VDD.$305.li1 sky130_gnd 0.0290873f
Cext_6817 VDD.$306.li1 sky130_gnd 0.0122649f
Cext_6818 VDD.$308.li1 sky130_gnd 0.0081986f
Cext_6819 VDD.$310.li1 sky130_gnd 0.0081986f
Cext_6820 VDD.$312.li1 sky130_gnd 0.0081986f
Cext_6821 VDD.$314.li1 sky130_gnd 0.0081986f
Cext_6822 VDD.$316.li1 sky130_gnd 0.00789852f
Cext_6823 VDD.$318.li1 sky130_gnd 0.0081986f
Cext_6824 VDD.$32.li1 sky130_gnd 0.011863f
Cext_6825 VDD.$320.li1 sky130_gnd 0.0081986f
Cext_6826 VDD.$322.li1 sky130_gnd 0.0081986f
Cext_6827 VDD.$324.li1 sky130_gnd 0.0081986f
Cext_6828 VDD.$326.li1 sky130_gnd 0.0122649f
Cext_6829 VDD.$328.li1 sky130_gnd 0.0120383f
Cext_6830 VDD.$329.li1 VSS.$489.poly 0.00104013f
Cext_6831 VDD.$329.li1 sky130_gnd 0.00796218f
Cext_6832 VDD.$330.li1 sky130_gnd 0.00796218f
Cext_6833 VDD.$331.li1 sky130_gnd 0.0111447f
Cext_6834 VDD.$332.li1 sky130_gnd 0.0115425f
Cext_6835 VDD.$333.li1 sky130_gnd 0.00563574f
Cext_6836 VDD.$334.li1 sky130_gnd 0.0115425f
Cext_6837 VDD.$335.li1 sky130_gnd 0.0115425f
Cext_6838 VDD.$336.li1 sky130_gnd 0.0115425f
Cext_6839 VDD.$337.li1 sky130_gnd 0.0115425f
Cext_6840 VDD.$338.li1 sky130_gnd 0.0154694f
Cext_6841 VDD.$339.li1 sky130_gnd 0.0330636f
Cext_6842 VDD.$34.li1 sky130_gnd 0.011863f
Cext_6843 VDD.$340.li1 VSS.$477.poly 0.00137948f
Cext_6844 VDD.$340.li1 VSS.P0.poly 0.0157255f
Cext_6845 VDD.$340.li1 sky130_gnd 0.0162757f
Cext_6846 VDD.$342.li1 sky130_gnd 0.0194567f
Cext_6847 VDD.$343.li1 VSS.$519.poly 0.00237654f
Cext_6848 VDD.$343.li1 sky130_gnd 0.040551f
Cext_6849 VDD.$344.met1 sky130_gnd 0.0164192f
Cext_6850 VDD.$345.met1 sky130_gnd 0.00723542f
Cext_6851 VDD.$346.met1 sky130_gnd 0.0109688f
Cext_6852 VDD.$347.met1 sky130_gnd 0.0127043f
Cext_6853 VDD.$348.met1 sky130_gnd 0.0127043f
Cext_6854 VDD.$349.met1 sky130_gnd 0.0127043f
Cext_6855 VDD.$350.met1 sky130_gnd 0.0127043f
Cext_6856 VDD.$351.met1 sky130_gnd 0.0127043f
Cext_6857 VDD.$352.met1 sky130_gnd 0.0127043f
Cext_6858 VDD.$353.met1 sky130_gnd 0.0127043f
Cext_6859 VDD.$354.met1 sky130_gnd 0.0127043f
Cext_6860 VDD.$355.met1 sky130_gnd 0.0127043f
Cext_6861 VDD.$356.met1 sky130_gnd 0.0127043f
Cext_6862 VDD.$357.met1 sky130_gnd 0.0127043f
Cext_6863 VDD.$358.met1 sky130_gnd 0.0127043f
Cext_6864 VDD.$359.met1 sky130_gnd 0.0127043f
Cext_6865 VDD.$36.li1 sky130_gnd 0.011863f
Cext_6866 VDD.$360.met1 sky130_gnd 0.0127043f
Cext_6867 VDD.$361.met1 sky130_gnd 0.0127043f
Cext_6868 VDD.$362.met1 sky130_gnd 0.0127043f
Cext_6869 VDD.$363.met1 sky130_gnd 0.0127043f
Cext_6870 VDD.$364.met1 sky130_gnd 0.0127043f
Cext_6871 VDD.$365.met1 sky130_gnd 0.0127043f
Cext_6872 VDD.$366.met1 sky130_gnd 0.0180775f
Cext_6873 VDD.$367.met1 sky130_gnd 0.0249824f
Cext_6874 VDD.$369.met1 sky130_gnd 0.00931062f
Cext_6875 VDD.$370.met1 sky130_gnd 0.00715201f
Cext_6876 VDD.$371.met1 sky130_gnd 0.00675905f
Cext_6877 VDD.$372.met1 sky130_gnd 0.00772664f
Cext_6878 VDD.$373.met1 sky130_gnd 0.00772664f
Cext_6879 VDD.$374.met1 sky130_gnd 0.00772664f
Cext_6880 VDD.$375.met1 sky130_gnd 0.00772664f
Cext_6881 VDD.$376.met1 sky130_gnd 0.00772664f
Cext_6882 VDD.$377.met1 sky130_gnd 0.00772664f
Cext_6883 VDD.$378.met1 sky130_gnd 0.00772664f
Cext_6884 VDD.$379.met1 sky130_gnd 0.00772664f
Cext_6885 VDD.$38.li1 sky130_gnd 0.011863f
Cext_6886 VDD.$380.met1 sky130_gnd 0.00751137f
Cext_6887 VDD.$381.met1 sky130_gnd 0.00751137f
Cext_6888 VDD.$382.met1 sky130_gnd 0.00772664f
Cext_6889 VDD.$383.met1 sky130_gnd 0.00772664f
Cext_6890 VDD.$384.met1 sky130_gnd 0.00772664f
Cext_6891 VDD.$385.met1 sky130_gnd 0.00772664f
Cext_6892 VDD.$386.met1 sky130_gnd 0.00772664f
Cext_6893 VDD.$387.met1 sky130_gnd 0.00772664f
Cext_6894 VDD.$388.met1 sky130_gnd 0.00772664f
Cext_6895 VDD.$389.met1 sky130_gnd 0.00772664f
Cext_6896 VDD.$390.met1 sky130_gnd 0.00772664f
Cext_6897 VDD.$391.met1 sky130_gnd 0.0135837f
Cext_6898 VDD.$392.met1 sky130_gnd 0.0249824f
Cext_6899 VDD.$394.met1 sky130_gnd 0.0139569f
Cext_6900 VDD.$395.met1 VREF.$64.met1 0.00159039f
Cext_6901 VDD.$395.met1 sky130_gnd 0.00772664f
Cext_6902 VDD.$396.met1 VREF.$65.met1 0.00183333f
Cext_6903 VDD.$396.met1 sky130_gnd 0.00772664f
Cext_6904 VDD.$397.met1 VREF.$66.met1 0.00183333f
Cext_6905 VDD.$397.met1 sky130_gnd 0.00772664f
Cext_6906 VDD.$398.met1 VREF.$67.met1 0.00183333f
Cext_6907 VDD.$398.met1 sky130_gnd 0.00772664f
Cext_6908 VDD.$399.met1 VREF.$68.met1 0.00183333f
Cext_6909 VDD.$399.met1 sky130_gnd 0.00772664f
Cext_6910 VDD.$4.li1 sky130_gnd 0.011863f
Cext_6911 VDD.$40.li1 sky130_gnd 0.011863f
Cext_6912 VDD.$400.met1 VREF.$69.met1 0.00183333f
Cext_6913 VDD.$400.met1 sky130_gnd 0.00772664f
Cext_6914 VDD.$401.met1 VREF.$70.met1 0.00183333f
Cext_6915 VDD.$401.met1 sky130_gnd 0.00772664f
Cext_6916 VDD.$402.met1 VREF.$71.met1 0.00183333f
Cext_6917 VDD.$402.met1 sky130_gnd 0.00772664f
Cext_6918 VDD.$403.met1 VREF.$72.met1 0.00183333f
Cext_6919 VDD.$403.met1 sky130_gnd 0.00772664f
Cext_6920 VDD.$404.met1 VREF.$73.met1 0.00183333f
Cext_6921 VDD.$404.met1 sky130_gnd 0.00751137f
Cext_6922 VDD.$405.met1 VREF.$74.met1 0.00183333f
Cext_6923 VDD.$405.met1 sky130_gnd 0.00751137f
Cext_6924 VDD.$406.met1 VREF.$75.met1 0.00183333f
Cext_6925 VDD.$406.met1 sky130_gnd 0.00772664f
Cext_6926 VDD.$407.met1 VREF.$76.met1 0.00183333f
Cext_6927 VDD.$407.met1 sky130_gnd 0.00772664f
Cext_6928 VDD.$408.met1 VREF.$77.met1 0.00183333f
Cext_6929 VDD.$408.met1 sky130_gnd 0.00772664f
Cext_6930 VDD.$409.met1 VREF.$78.met1 0.00183333f
Cext_6931 VDD.$409.met1 sky130_gnd 0.00772664f
Cext_6932 VDD.$410.met1 VREF.$79.met1 0.00183333f
Cext_6933 VDD.$410.met1 sky130_gnd 0.00772664f
Cext_6934 VDD.$411.met1 VREF.$80.met1 0.00183333f
Cext_6935 VDD.$411.met1 sky130_gnd 0.00772664f
Cext_6936 VDD.$412.met1 VREF.$81.met1 0.00183333f
Cext_6937 VDD.$412.met1 sky130_gnd 0.00772664f
Cext_6938 VDD.$413.met1 VREF.$82.met1 0.00183333f
Cext_6939 VDD.$413.met1 sky130_gnd 0.00772664f
Cext_6940 VDD.$414.met1 VREF.$83.met1 0.00183333f
Cext_6941 VDD.$414.met1 sky130_gnd 0.00772664f
Cext_6942 VDD.$415.met1 VREF.$84.met1 0.00165509f
Cext_6943 VDD.$415.met1 sky130_gnd 0.0135837f
Cext_6944 VDD.$416.met1 VREF.$63.met1 0.00117464f
Cext_6945 VDD.$417.met1 VREF.$73.met1 0.00424759f
Cext_6946 VDD.$417.met1 VREF.$74.met1 0.00409302f
Cext_6947 VDD.$417.met1 sky130_gnd 0.0249824f
Cext_6948 VDD.$419.met1 VREF.$85.met1 0.00217055f
Cext_6949 VDD.$419.met1 sky130_gnd 0.0119667f
Cext_6950 VDD.$42.li1 sky130_gnd 0.0157213f
Cext_6951 VDD.$420.met1 sky130_gnd 0.0076323f
Cext_6952 VDD.$421.met1 VREF.$64.met1 0.00205965f
Cext_6953 VDD.$421.met1 sky130_gnd 0.00667109f
Cext_6954 VDD.$422.met1 VREF.$65.met1 0.00238554f
Cext_6955 VDD.$422.met1 sky130_gnd 0.00772664f
Cext_6956 VDD.$423.met1 VREF.$66.met1 0.00238554f
Cext_6957 VDD.$423.met1 sky130_gnd 0.00772664f
Cext_6958 VDD.$424.met1 VREF.$67.met1 0.00238554f
Cext_6959 VDD.$424.met1 sky130_gnd 0.00772664f
Cext_6960 VDD.$425.met1 VREF.$68.met1 0.00238554f
Cext_6961 VDD.$425.met1 sky130_gnd 0.00772664f
Cext_6962 VDD.$426.met1 VREF.$69.met1 0.00238554f
Cext_6963 VDD.$426.met1 sky130_gnd 0.00772664f
Cext_6964 VDD.$427.met1 VREF.$70.met1 0.00238554f
Cext_6965 VDD.$427.met1 sky130_gnd 0.00772664f
Cext_6966 VDD.$428.met1 VREF.$71.met1 0.00238554f
Cext_6967 VDD.$428.met1 sky130_gnd 0.00772664f
Cext_6968 VDD.$429.met1 VREF.$72.met1 0.00238554f
Cext_6969 VDD.$429.met1 sky130_gnd 0.00772664f
Cext_6970 VDD.$430.met1 VREF.$73.met1 0.0013253f
Cext_6971 VDD.$430.met1 sky130_gnd 0.00751137f
Cext_6972 VDD.$431.met1 VREF.$74.met1 0.0013253f
Cext_6973 VDD.$431.met1 sky130_gnd 0.00751137f
Cext_6974 VDD.$432.met1 VREF.$75.met1 0.00238554f
Cext_6975 VDD.$432.met1 sky130_gnd 0.00772664f
Cext_6976 VDD.$433.met1 VREF.$76.met1 0.00238554f
Cext_6977 VDD.$433.met1 sky130_gnd 0.00772664f
Cext_6978 VDD.$434.met1 VREF.$77.met1 0.00238554f
Cext_6979 VDD.$434.met1 sky130_gnd 0.00772664f
Cext_6980 VDD.$435.met1 VREF.$78.met1 0.00238554f
Cext_6981 VDD.$435.met1 sky130_gnd 0.00772664f
Cext_6982 VDD.$436.met1 VREF.$79.met1 0.00238554f
Cext_6983 VDD.$436.met1 sky130_gnd 0.00772664f
Cext_6984 VDD.$437.met1 VREF.$80.met1 0.00238554f
Cext_6985 VDD.$437.met1 sky130_gnd 0.00772664f
Cext_6986 VDD.$438.met1 VREF.$81.met1 0.00238554f
Cext_6987 VDD.$438.met1 sky130_gnd 0.00772664f
Cext_6988 VDD.$439.met1 VREF.$82.met1 0.00238554f
Cext_6989 VDD.$439.met1 sky130_gnd 0.00772664f
Cext_6990 VDD.$44.li1 sky130_gnd 0.011604f
Cext_6991 VDD.$440.met1 VREF.$83.met1 0.00238554f
Cext_6992 VDD.$440.met1 sky130_gnd 0.00772664f
Cext_6993 VDD.$441.met1 VREF.$84.met1 0.00215361f
Cext_6994 VDD.$441.met1 sky130_gnd 0.0135837f
Cext_6995 VDD.$442.met1 sky130_gnd 0.0249824f
Cext_6996 VDD.$444.met1 sky130_gnd 0.0146188f
Cext_6997 VDD.$445.met1 sky130_gnd 0.00787112f
Cext_6998 VDD.$446.met1 sky130_gnd 0.00772664f
Cext_6999 VDD.$447.met1 sky130_gnd 0.00772664f
Cext_7000 VDD.$448.met1 sky130_gnd 0.00772664f
Cext_7001 VDD.$449.met1 sky130_gnd 0.00772664f
Cext_7002 VDD.$45.li1 sky130_gnd 0.00796218f
Cext_7003 VDD.$450.met1 sky130_gnd 0.00772664f
Cext_7004 VDD.$451.met1 sky130_gnd 0.00772664f
Cext_7005 VDD.$452.met1 sky130_gnd 0.00772664f
Cext_7006 VDD.$453.met1 sky130_gnd 0.00772664f
Cext_7007 VDD.$454.met1 sky130_gnd 0.0135045f
Cext_7008 VDD.$456.met1 sky130_gnd 0.0267809f
Cext_7009 VDD.$458.met1 sky130_gnd 0.0114749f
Cext_7010 VDD.$459.met1 sky130_gnd 0.00973222f
Cext_7011 VDD.$46.li1 sky130_gnd 0.00796218f
Cext_7012 VDD.$460.met1 sky130_gnd 0.00598647f
Cext_7013 VDD.$461.met1 sky130_gnd 0.00772664f
Cext_7014 VDD.$462.met1 sky130_gnd 0.00772664f
Cext_7015 VDD.$463.met1 sky130_gnd 0.00772664f
Cext_7016 VDD.$464.met1 sky130_gnd 0.0072961f
Cext_7017 VDD.$465.met1 sky130_gnd 0.00772664f
Cext_7018 VDD.$466.met1 sky130_gnd 0.00772664f
Cext_7019 VDD.$467.met1 sky130_gnd 0.00772664f
Cext_7020 VDD.$468.met1 sky130_gnd 0.00772664f
Cext_7021 VDD.$469.met1 sky130_gnd 0.0136457f
Cext_7022 VDD.$47.li1 sky130_gnd 0.00796218f
Cext_7023 VDD.$470.met1 sky130_gnd 0.0324775f
Cext_7024 VDD.$472.met1 VSS.P0.poly 0.00643848f
Cext_7025 VDD.$472.met1 sky130_gnd 0.0171016f
Cext_7026 VDD.$473.met1 VSS.P0.poly 0.0125265f
Cext_7027 VDD.$473.met1 sky130_gnd 0.0126388f
Cext_7028 VDD.$474.met1 sky130_gnd 0.036455f
Cext_7029 VDD.$476.met2 sky130_gnd 0.0446621f
Cext_7030 VDD.$477.met2 sky130_gnd 0.046913f
Cext_7031 VDD.$478.met2 sky130_gnd 0.173036f
Cext_7032 VDD.$479.met2 sky130_gnd 0.0616895f
Cext_7033 VDD.$48.li1 sky130_gnd 0.00796218f
Cext_7034 VDD.$480.met2 sky130_gnd 0.017725f
Cext_7035 VDD.$481.met2 sky130_gnd 0.186312f
Cext_7036 VDD.$482.met2 VREF.$101.met2 0.00273136f
Cext_7037 VDD.$482.met2 sky130_gnd 0.0202046f
Cext_7038 VDD.$483.met2 sky130_gnd 0.0497721f
Cext_7039 VDD.$484.met2 VREF.$73.met1 0.00178543f
Cext_7040 VDD.$484.met2 VREF.$74.met1 0.00697369f
Cext_7041 VDD.$484.met2 VREF.$75.met1 0.00291426f
Cext_7042 VDD.$484.met2 sky130_gnd 0.189257f
Cext_7043 VDD.$485.met2 sky130_gnd 0.0488987f
Cext_7044 VDD.$486.met2 VREF.$101.met2 0.00371342f
Cext_7045 VDD.$486.met2 sky130_gnd 0.0285747f
Cext_7046 VDD.$487.met2 sky130_gnd 0.128198f
Cext_7047 VDD.$488.met2 sky130_gnd 0.0200102f
Cext_7048 VDD.$489.met2 sky130_gnd 0.123983f
Cext_7049 VDD.$49.li1 sky130_gnd 0.00796218f
Cext_7050 VDD.$490.met2 sky130_gnd 0.0819895f
Cext_7051 VDD.$491.met2 sky130_gnd 0.0685364f
Cext_7052 VDD.$492.met2 sky130_gnd 0.0354324f
Cext_7053 VDD.$493.met2 sky130_gnd 0.0671815f
Cext_7054 VDD.$494.met2 VSS.$329.met1 0.00132589f
Cext_7055 VDD.$494.met2 VSS.$493.poly 0.0034832f
Cext_7056 VDD.$494.met2 sky130_gnd 0.110628f
Cext_7057 VDD.$495.met2 VSS.$477.poly 0.00220087f
Cext_7058 VDD.$495.met2 VSS.P0.poly 0.00289125f
Cext_7059 VDD.$495.met2 sky130_gnd 0.0913941f
Cext_7060 VDD.$496.met2 VSS.$497.poly 0.00211986f
Cext_7061 VDD.$496.met2 VSS.P0.poly 0.0119282f
Cext_7062 VDD.$496.met2 sky130_gnd 0.0154976f
Cext_7063 VDD.$497.met2 net1.$621.met3 0.00364459f
Cext_7064 VDD.$497.met2 VREF.$110.met3 0.112151f
Cext_7065 VDD.$497.met2 sky130_gnd 1.31724f
Cext_7066 VDD.$498.met2 sky130_gnd 0.0128458f
Cext_7067 VDD.$499.met2 VSS.$354.met1 0.00125604f
Cext_7068 VDD.$499.met2 sky130_gnd 0.909581f
Cext_7069 VDD.$50.li1 sky130_gnd 0.00796218f
Cext_7070 VDD.$500.met3 sky130_gnd 0.053703f
Cext_7071 VDD.$501.met3 sky130_gnd 0.0925445f
Cext_7072 VDD.$502.met3 VREF.$6.li1 0.00415288f
Cext_7073 VDD.$502.met3 VREF.$66.met1 0.00989211f
Cext_7074 VDD.$502.met3 sky130_gnd 0.203807f
Cext_7075 VDD.$503.met3 VREF.$101.met2 0.0183305f
Cext_7076 VDD.$503.met3 VREF.$65.met1 0.00473321f
Cext_7077 VDD.$503.met3 VREF.$66.met1 0.0108808f
Cext_7078 VDD.$503.met3 VREF.$67.met1 0.00144442f
Cext_7079 VDD.$503.met3 VREF.$76.met1 0.0127267f
Cext_7080 VDD.$503.met3 VREF.P0.psdm 0.00689471f
Cext_7081 VDD.$503.met3 sky130_gnd 0.195453f
Cext_7082 VDD.$504.met3 sky130_gnd 0.107777f
Cext_7083 VDD.$505.met3 sky130_gnd 0.114724f
Cext_7084 VDD.$506.met3 sky130_gnd 0.0890299f
Cext_7085 VDD.$507.met3 VSS.$311.met1 0.00334132f
Cext_7086 VDD.$507.met3 VSS.$312.met1 0.00371453f
Cext_7087 VDD.$507.met3 VSS.$313.met1 0.00301554f
Cext_7088 VDD.$507.met3 VSS.$314.met1 0.00422487f
Cext_7089 VDD.$507.met3 VSS.$316.met1 0.00283799f
Cext_7090 VDD.$507.met3 VSS.$317.met1 0.00431544f
Cext_7091 VDD.$507.met3 VSS.$318.met1 0.00370115f
Cext_7092 VDD.$507.met3 VSS.$319.met1 0.00394669f
Cext_7093 VDD.$507.met3 VSS.$320.met1 0.00407106f
Cext_7094 VDD.$507.met3 VSS.$321.met1 0.00432838f
Cext_7095 VDD.$507.met3 VSS.$322.met1 0.00395821f
Cext_7096 VDD.$507.met3 VSS.$323.met1 0.00421193f
Cext_7097 VDD.$507.met3 VSS.$324.met1 0.00371996f
Cext_7098 VDD.$507.met3 VSS.$325.met1 0.0039661f
Cext_7099 VDD.$507.met3 VSS.$326.met1 0.00415256f
Cext_7100 VDD.$507.met3 VSS.$327.met1 0.00441248f
Cext_7101 VDD.$507.met3 VSS.$328.met1 0.00385789f
Cext_7102 VDD.$507.met3 VSS.$329.met1 0.00410842f
Cext_7103 VDD.$507.met3 VSS.$330.met1 0.00382028f
Cext_7104 VDD.$507.met3 VSS.$331.met1 0.00406961f
Cext_7105 VDD.$507.met3 VSS.$332.met1 0.00415256f
Cext_7106 VDD.$507.met3 VSS.$333.met1 0.00441248f
Cext_7107 VDD.$507.met3 VSS.$334.met1 0.00308932f
Cext_7108 VDD.$507.met3 VSS.$335.met1 0.00329232f
Cext_7109 VDD.$507.met3 VSS.$411.met2 0.0418398f
Cext_7110 VDD.$507.met3 VSS.$477.poly 0.00625875f
Cext_7111 VDD.$507.met3 VSS.$479.poly 0.00473235f
Cext_7112 VDD.$507.met3 VSS.$481.poly 0.004864f
Cext_7113 VDD.$507.met3 VSS.$483.poly 0.00570459f
Cext_7114 VDD.$507.met3 VSS.$485.poly 0.00502949f
Cext_7115 VDD.$507.met3 VSS.$487.poly 0.00498866f
Cext_7116 VDD.$507.met3 VSS.$489.poly 0.00571139f
Cext_7117 VDD.$507.met3 VSS.$491.poly 0.00505898f
Cext_7118 VDD.$507.met3 VSS.$493.poly 0.00495237f
Cext_7119 VDD.$507.met3 VSS.$495.poly 0.00505904f
Cext_7120 VDD.$507.met3 VSS.$497.poly 0.00257143f
Cext_7121 VDD.$507.met3 VSS.$499.poly 0.00212531f
Cext_7122 VDD.$507.met3 VSS.P0.poly 0.00548749f
Cext_7123 VDD.$507.met3 sky130_gnd 0.185366f
Cext_7124 VDD.$508.met3 net1.$621.met3 0.0883889f
Cext_7125 VDD.$508.met3 net1.$622.met3 0.17575f
Cext_7126 VDD.$508.met3 net2.$91.met3 0.434699f
Cext_7127 VDD.$508.met3 net2.$92.met3 0.0765411f
Cext_7128 VDD.$508.met3 sky130_gnd 1.99129f
Cext_7129 VDD.$509.met3 VSS.$336.met1 0.00392059f
Cext_7130 VDD.$509.met3 VSS.$337.met1 0.00417312f
Cext_7131 VDD.$509.met3 VSS.$338.met1 0.00410867f
Cext_7132 VDD.$509.met3 VSS.$339.met1 0.0043672f
Cext_7133 VDD.$509.met3 VSS.$340.met1 0.00370115f
Cext_7134 VDD.$509.met3 VSS.$341.met1 0.00394669f
Cext_7135 VDD.$509.met3 VSS.$342.met1 0.0040209f
Cext_7136 VDD.$509.met3 VSS.$343.met1 0.00427663f
Cext_7137 VDD.$509.met3 VSS.$344.met1 0.00400836f
Cext_7138 VDD.$509.met3 VSS.$345.met1 0.00426369f
Cext_7139 VDD.$509.met3 VSS.$346.met1 0.00370115f
Cext_7140 VDD.$509.met3 VSS.$347.met1 0.00394669f
Cext_7141 VDD.$509.met3 VSS.$348.met1 0.00412121f
Cext_7142 VDD.$509.met3 VSS.$349.met1 0.00438014f
Cext_7143 VDD.$509.met3 VSS.$350.met1 0.00390805f
Cext_7144 VDD.$509.met3 VSS.$351.met1 0.00416018f
Cext_7145 VDD.$509.met3 VSS.$352.met1 0.00371244f
Cext_7146 VDD.$509.met3 VSS.$353.met1 0.00398929f
Cext_7147 VDD.$509.met3 VSS.$355.met1 0.00209022f
Cext_7148 VDD.$509.met3 VSS.$501.poly 0.00434441f
Cext_7149 VDD.$509.met3 VSS.$503.poly 0.0050431f
Cext_7150 VDD.$509.met3 VSS.$505.poly 0.020925f
Cext_7151 VDD.$509.met3 VSS.$507.poly 0.00501135f
Cext_7152 VDD.$509.met3 VSS.$509.poly 0.00500681f
Cext_7153 VDD.$509.met3 VSS.$511.poly 0.00570459f
Cext_7154 VDD.$509.met3 VSS.$513.poly 0.00504764f
Cext_7155 VDD.$509.met3 VSS.$515.poly 0.00497052f
Cext_7156 VDD.$509.met3 VSS.$517.poly 0.00564371f
Cext_7157 VDD.$509.met3 VSS.$519.poly 0.00112485f
Cext_7158 VDD.$509.met3 VSS.P0.poly 0.00117021f
Cext_7159 VDD.$509.met3 sky130_gnd 0.210173f
Cext_7160 VDD.$51.li1 sky130_gnd 0.00796218f
Cext_7161 VDD.$510.met3 net1.$622.met3 0.265094f
Cext_7162 VDD.$510.met3 VREF.$106.met2 0.00867815f
Cext_7163 VDD.$510.met3 VREF.$93.met1 0.00170781f
Cext_7164 VDD.$510.met3 VREF.$95.met1 0.00141604f
Cext_7165 VDD.$510.met3 VREF.$96.met1 0.0019394f
Cext_7166 VDD.$510.met3 VREF.$97.met1 0.00249384f
Cext_7167 VDD.$510.met3 sky130_gnd 0.134291f
Cext_7168 VDD.$511.met3 net2.$92.met3 0.155858f
Cext_7169 VDD.$511.met3 VREF.$117.poly 0.00171526f
Cext_7170 VDD.$511.met3 VREF.P1.poly 0.0103379f
Cext_7171 VDD.$511.met3 sky130_gnd 5.70492f
Cext_7172 VDD.$52.li1 sky130_gnd 0.00796218f
Cext_7173 VDD.$53.li1 sky130_gnd 0.00796218f
Cext_7174 VDD.$54.li1 sky130_gnd 0.00496031f
Cext_7175 VDD.$55.li1 sky130_gnd 0.00501249f
Cext_7176 VDD.$56.li1 sky130_gnd 0.00796218f
Cext_7177 VDD.$57.li1 sky130_gnd 0.00796218f
Cext_7178 VDD.$58.li1 sky130_gnd 0.00796218f
Cext_7179 VDD.$586.met4 net1.$622.met3 0.0973461f
Cext_7180 VDD.$586.met4 net2.$92.met3 0.0507324f
Cext_7181 VDD.$586.met4 VREF.$97.met1 0.00174365f
Cext_7182 VDD.$586.met4 sky130_gnd 0.11876f
Cext_7183 VDD.$587.met4 sky130_gnd 0.037156f
Cext_7184 VDD.$588.met4 sky130_gnd 0.0479998f
Cext_7185 VDD.$589.met4 sky130_gnd 0.0182608f
Cext_7186 VDD.$59.li1 sky130_gnd 0.00796218f
Cext_7187 VDD.$590.met4 sky130_gnd 0.0171566f
Cext_7188 VDD.$591.met4 sky130_gnd 0.0193651f
Cext_7189 VDD.$592.met4 sky130_gnd 0.0146209f
Cext_7190 VDD.$593.met4 sky130_gnd 0.0182608f
Cext_7191 VDD.$594.met4 sky130_gnd 0.0182608f
Cext_7192 VDD.$595.met4 sky130_gnd 0.0171566f
Cext_7193 VDD.$596.met4 sky130_gnd 0.0193651f
Cext_7194 VDD.$597.met4 sky130_gnd 0.0146209f
Cext_7195 VDD.$598.met4 sky130_gnd 0.0182608f
Cext_7196 VDD.$599.met4 sky130_gnd 0.0182608f
Cext_7197 VDD.$6.li1 sky130_gnd 0.011863f
Cext_7198 VDD.$60.li1 sky130_gnd 0.00796218f
Cext_7199 VDD.$600.met4 sky130_gnd 0.0171566f
Cext_7200 VDD.$601.met4 sky130_gnd 0.0193651f
Cext_7201 VDD.$602.met4 sky130_gnd 0.0146209f
Cext_7202 VDD.$603.met4 sky130_gnd 0.0182608f
Cext_7203 VDD.$604.met4 sky130_gnd 0.0182608f
Cext_7204 VDD.$605.met4 sky130_gnd 0.0171566f
Cext_7205 VDD.$606.met4 sky130_gnd 0.0193651f
Cext_7206 VDD.$607.met4 sky130_gnd 0.0146209f
Cext_7207 VDD.$608.met4 sky130_gnd 0.0182608f
Cext_7208 VDD.$609.met4 sky130_gnd 0.0182608f
Cext_7209 VDD.$61.li1 sky130_gnd 0.00796218f
Cext_7210 VDD.$610.met4 sky130_gnd 0.0171566f
Cext_7211 VDD.$611.met4 sky130_gnd 0.0193651f
Cext_7212 VDD.$612.met4 sky130_gnd 0.0146209f
Cext_7213 VDD.$613.met4 sky130_gnd 0.0182608f
Cext_7214 VDD.$614.met4 sky130_gnd 0.0182608f
Cext_7215 VDD.$615.met4 sky130_gnd 0.0171566f
Cext_7216 VDD.$616.met4 sky130_gnd 0.0193651f
Cext_7217 VDD.$617.met4 sky130_gnd 0.0146209f
Cext_7218 VDD.$618.met4 sky130_gnd 0.0182608f
Cext_7219 VDD.$619.met4 sky130_gnd 0.0182608f
Cext_7220 VDD.$62.li1 sky130_gnd 0.00796218f
Cext_7221 VDD.$620.met4 sky130_gnd 0.0171566f
Cext_7222 VDD.$621.met4 sky130_gnd 0.0193651f
Cext_7223 VDD.$622.met4 sky130_gnd 0.0146209f
Cext_7224 VDD.$623.met4 sky130_gnd 0.0182608f
Cext_7225 VDD.$624.met4 sky130_gnd 0.0182608f
Cext_7226 VDD.$625.met4 sky130_gnd 0.0171566f
Cext_7227 VDD.$626.met4 sky130_gnd 0.0193651f
Cext_7228 VDD.$627.met4 sky130_gnd 0.0146209f
Cext_7229 VDD.$628.met4 sky130_gnd 0.0182608f
Cext_7230 VDD.$629.met4 sky130_gnd 0.0182608f
Cext_7231 VDD.$63.li1 sky130_gnd 0.00796218f
Cext_7232 VDD.$630.met4 sky130_gnd 0.0171566f
Cext_7233 VDD.$631.met4 sky130_gnd 0.0193651f
Cext_7234 VDD.$632.met4 sky130_gnd 0.0146209f
Cext_7235 VDD.$633.met4 sky130_gnd 0.0182608f
Cext_7236 VDD.$634.met4 sky130_gnd 0.0182608f
Cext_7237 VDD.$635.met4 sky130_gnd 0.0171566f
Cext_7238 VDD.$636.met4 sky130_gnd 0.0193651f
Cext_7239 VDD.$637.met4 sky130_gnd 0.0146209f
Cext_7240 VDD.$638.met4 sky130_gnd 0.0182608f
Cext_7241 VDD.$639.met4 sky130_gnd 0.0182608f
Cext_7242 VDD.$64.li1 sky130_gnd 0.00796218f
Cext_7243 VDD.$640.met4 sky130_gnd 0.0171566f
Cext_7244 VDD.$641.met4 sky130_gnd 0.0193651f
Cext_7245 VDD.$642.met4 sky130_gnd 0.0146209f
Cext_7246 VDD.$643.met4 sky130_gnd 0.0182608f
Cext_7247 VDD.$644.met4 sky130_gnd 0.0182608f
Cext_7248 VDD.$645.met4 sky130_gnd 0.0171566f
Cext_7249 VDD.$646.met4 sky130_gnd 0.0193651f
Cext_7250 VDD.$647.met4 sky130_gnd 0.0146209f
Cext_7251 VDD.$648.met4 sky130_gnd 0.0182608f
Cext_7252 VDD.$649.met4 sky130_gnd 0.0182608f
Cext_7253 VDD.$65.li1 sky130_gnd 0.0119831f
Cext_7254 VDD.$650.met4 sky130_gnd 0.0171566f
Cext_7255 VDD.$651.met4 sky130_gnd 0.0193651f
Cext_7256 VDD.$652.met4 sky130_gnd 0.0146209f
Cext_7257 VDD.$653.met4 sky130_gnd 0.0182608f
Cext_7258 VDD.$654.met4 sky130_gnd 0.0181618f
Cext_7259 VDD.$655.met4 sky130_gnd 0.0171566f
Cext_7260 VDD.$656.met4 sky130_gnd 0.019266f
Cext_7261 VDD.$657.met4 sky130_gnd 0.0146209f
Cext_7262 VDD.$658.met4 sky130_gnd 0.0182608f
Cext_7263 VDD.$659.met4 sky130_gnd 0.0353852f
Cext_7264 VDD.$66.li1 sky130_gnd 0.00106807f
Cext_7265 VDD.$660.met4 sky130_gnd 0.0146209f
Cext_7266 VDD.$661.met4 net2.$92.met3 0.0538325f
Cext_7267 VDD.$661.met4 sky130_gnd 0.137031f
Cext_7268 VDD.$67.li1 sky130_gnd 0.0261754f
Cext_7269 VDD.$68.li1 sky130_gnd 0.0116773f
Cext_7270 VDD.$684.nwell VREF.$101.met2 0.00195291f
Cext_7271 VDD.$70.li1 sky130_gnd 0.0081986f
Cext_7272 VDD.$706.nwell VREF.$0.li1 0.00236608f
Cext_7273 VDD.$706.nwell VREF.$101.met2 0.0191717f
Cext_7274 VDD.$706.nwell VREF.$63.met1 0.00422828f
Cext_7275 VDD.$706.nwell VREF.$85.met1 0.00144078f
Cext_7276 VDD.$707.nwell VREF.$64.met1 0.00172445f
Cext_7277 VDD.$708.nwell VREF.$65.met1 0.00204366f
Cext_7278 VDD.$709.nwell VREF.$66.met1 0.00211832f
Cext_7279 VDD.$710.nwell VREF.$67.met1 0.00204366f
Cext_7280 VDD.$711.nwell VREF.$68.met1 0.00211832f
Cext_7281 VDD.$712.nwell VREF.$69.met1 0.00211832f
Cext_7282 VDD.$713.nwell VREF.$70.met1 0.00211832f
Cext_7283 VDD.$714.nwell VREF.$71.met1 0.00167872f
Cext_7284 VDD.$715.nwell VREF.$72.met1 0.00158074f
Cext_7285 VDD.$718.nwell VREF.$75.met1 0.00158074f
Cext_7286 VDD.$719.nwell VREF.$76.met1 0.00167872f
Cext_7287 VDD.$72.li1 sky130_gnd 0.0081986f
Cext_7288 VDD.$720.nwell VREF.$77.met1 0.00211832f
Cext_7289 VDD.$721.nwell VREF.$78.met1 0.00211832f
Cext_7290 VDD.$722.nwell VREF.$79.met1 0.00211832f
Cext_7291 VDD.$723.nwell VREF.$80.met1 0.00211832f
Cext_7292 VDD.$724.nwell VREF.$81.met1 0.00211832f
Cext_7293 VDD.$725.nwell VREF.$82.met1 0.00211832f
Cext_7294 VDD.$726.nwell VREF.$83.met1 0.00211832f
Cext_7295 VDD.$727.nwell VREF.$42.li1 0.00236608f
Cext_7296 VDD.$727.nwell VREF.$84.met1 0.00436503f
Cext_7297 VDD.$728.nwell VREF.$101.met2 0.00210776f
Cext_7298 VDD.$74.li1 sky130_gnd 0.0081986f
Cext_7299 VDD.$76.li1 sky130_gnd 0.0081986f
Cext_7300 VDD.$761.nwell VSS.$120.li1 0.00391144f
Cext_7301 VDD.$761.nwell VSS.$122.li1 0.00442742f
Cext_7302 VDD.$761.nwell VSS.$311.met1 0.00403894f
Cext_7303 VDD.$761.nwell VSS.$312.met1 0.00331298f
Cext_7304 VDD.$761.nwell VSS.$315.met1 0.00291571f
Cext_7305 VDD.$761.nwell VSS.$411.met2 0.00441966f
Cext_7306 VDD.$761.nwell VSS.$477.poly 0.0950856f
Cext_7307 VDD.$761.nwell VSS.$479.poly 0.00835045f
Cext_7308 VDD.$772.nwell VSS.$188.li1 0.00109086f
Cext_7309 VDD.$772.nwell VSS.$190.li1 0.00109086f
Cext_7310 VDD.$772.nwell VSS.$192.li1 0.00144114f
Cext_7311 VDD.$772.nwell VSS.$194.li1 0.00144114f
Cext_7312 VDD.$772.nwell VSS.$196.li1 0.00144114f
Cext_7313 VDD.$772.nwell VSS.$198.li1 0.00144114f
Cext_7314 VDD.$772.nwell VSS.$200.li1 0.00144114f
Cext_7315 VDD.$772.nwell VSS.$202.li1 0.00144114f
Cext_7316 VDD.$772.nwell VSS.$204.li1 0.00491809f
Cext_7317 VDD.$772.nwell VSS.$206.li1 0.00435652f
Cext_7318 VDD.$772.nwell VSS.$348.met1 0.0010666f
Cext_7319 VDD.$772.nwell VSS.$349.met1 0.0010666f
Cext_7320 VDD.$772.nwell VSS.$350.met1 0.0010666f
Cext_7321 VDD.$772.nwell VSS.$351.met1 0.0010666f
Cext_7322 VDD.$772.nwell VSS.$352.met1 0.0010666f
Cext_7323 VDD.$772.nwell VSS.$353.met1 0.0010666f
Cext_7324 VDD.$772.nwell VSS.$354.met1 0.0042215f
Cext_7325 VDD.$772.nwell VSS.$355.met1 0.0042215f
Cext_7326 VDD.$772.nwell VSS.$511.poly 0.0382928f
Cext_7327 VDD.$772.nwell VSS.$513.poly 0.0505886f
Cext_7328 VDD.$772.nwell VSS.$515.poly 0.0505886f
Cext_7329 VDD.$772.nwell VSS.$517.poly 0.0505886f
Cext_7330 VDD.$772.nwell VSS.$519.poly 0.103413f
Cext_7331 VDD.$78.li1 sky130_gnd 0.0081986f
Cext_7332 VDD.$8.li1 sky130_gnd 0.011863f
Cext_7333 VDD.$80.li1 sky130_gnd 0.0081986f
Cext_7334 VDD.$82.li1 sky130_gnd 0.0081986f
Cext_7335 VDD.$84.li1 sky130_gnd 0.0081986f
Cext_7336 VDD.$86.li1 sky130_gnd 0.0081986f
Cext_7337 VDD.$88.li1 sky130_gnd 0.00804856f
Cext_7338 VDD.$90.li1 sky130_gnd 0.00804856f
Cext_7339 VDD.$92.li1 sky130_gnd 0.0081986f
Cext_7340 VDD.$94.li1 sky130_gnd 0.0081986f
Cext_7341 VDD.$96.li1 sky130_gnd 0.0081986f
Cext_7342 VDD.$98.li1 sky130_gnd 0.0081986f
Cext_7343 VDD.P0.met3 net2.$62.met1 0.00776061f
Cext_7344 VDD.P0.met3 net2.$74.met1 0.00377765f
Cext_7345 VDD.P0.met3 net2.P0.li1 0.00319095f
Cext_7346 VDD.P0.met3 VSS.$116.li1 0.0252019f
Cext_7347 VDD.P0.met3 VSS.$425.met3 0.00440075f
Cext_7348 VDD.P0.met3 VSS.P16.li1 0.0181391f
Cext_7349 VDD.P0.met3 sky130_gnd 8.56789f
Cext_7350 VDD.P0.nwell VSS.$124.li1 0.00108618f
Cext_7351 VDD.P0.nwell VSS.$126.li1 0.00105897f
Cext_7352 VDD.P0.nwell VSS.$128.li1 0.00144114f
Cext_7353 VDD.P0.nwell VSS.$130.li1 0.00144114f
Cext_7354 VDD.P0.nwell VSS.$132.li1 0.00144114f
Cext_7355 VDD.P0.nwell VSS.$134.li1 0.00144114f
Cext_7356 VDD.P0.nwell VSS.$136.li1 0.00144114f
Cext_7357 VDD.P0.nwell VSS.$138.li1 0.00144114f
Cext_7358 VDD.P0.nwell VSS.$140.li1 0.00144114f
Cext_7359 VDD.P0.nwell VSS.$142.li1 0.00144114f
Cext_7360 VDD.P0.nwell VSS.$144.li1 0.00144114f
Cext_7361 VDD.P0.nwell VSS.$146.li1 0.00144114f
Cext_7362 VDD.P0.nwell VSS.$148.li1 0.00144114f
Cext_7363 VDD.P0.nwell VSS.$150.li1 0.00144114f
Cext_7364 VDD.P0.nwell VSS.$152.li1 0.00144114f
Cext_7365 VDD.P0.nwell VSS.$154.li1 0.00144114f
Cext_7366 VDD.P0.nwell VSS.$156.li1 0.00144114f
Cext_7367 VDD.P0.nwell VSS.$158.li1 0.00144114f
Cext_7368 VDD.P0.nwell VSS.$160.li1 0.00144114f
Cext_7369 VDD.P0.nwell VSS.$162.li1 0.00144114f
Cext_7370 VDD.P0.nwell VSS.$164.li1 0.00144114f
Cext_7371 VDD.P0.nwell VSS.$166.li1 0.00144114f
Cext_7372 VDD.P0.nwell VSS.$168.li1 0.00144114f
Cext_7373 VDD.P0.nwell VSS.$170.li1 0.00144114f
Cext_7374 VDD.P0.nwell VSS.$172.li1 0.00144114f
Cext_7375 VDD.P0.nwell VSS.$174.li1 0.00144114f
Cext_7376 VDD.P0.nwell VSS.$176.li1 0.00144114f
Cext_7377 VDD.P0.nwell VSS.$178.li1 0.00144114f
Cext_7378 VDD.P0.nwell VSS.$180.li1 0.00144114f
Cext_7379 VDD.P0.nwell VSS.$182.li1 0.00144114f
Cext_7380 VDD.P0.nwell VSS.$184.li1 0.00144114f
Cext_7381 VDD.P0.nwell VSS.$186.li1 0.00144114f
Cext_7382 VDD.P0.nwell VSS.$315.met1 0.0056218f
Cext_7383 VDD.P0.nwell VSS.$317.met1 0.0010666f
Cext_7384 VDD.P0.nwell VSS.$318.met1 0.0010666f
Cext_7385 VDD.P0.nwell VSS.$319.met1 0.0010666f
Cext_7386 VDD.P0.nwell VSS.$320.met1 0.0010666f
Cext_7387 VDD.P0.nwell VSS.$321.met1 0.0010666f
Cext_7388 VDD.P0.nwell VSS.$322.met1 0.0010666f
Cext_7389 VDD.P0.nwell VSS.$323.met1 0.0010666f
Cext_7390 VDD.P0.nwell VSS.$324.met1 0.0010666f
Cext_7391 VDD.P0.nwell VSS.$325.met1 0.0010666f
Cext_7392 VDD.P0.nwell VSS.$326.met1 0.0010666f
Cext_7393 VDD.P0.nwell VSS.$327.met1 0.0010666f
Cext_7394 VDD.P0.nwell VSS.$328.met1 0.0010666f
Cext_7395 VDD.P0.nwell VSS.$329.met1 0.0010666f
Cext_7396 VDD.P0.nwell VSS.$330.met1 0.0010666f
Cext_7397 VDD.P0.nwell VSS.$331.met1 0.0010666f
Cext_7398 VDD.P0.nwell VSS.$332.met1 0.0010666f
Cext_7399 VDD.P0.nwell VSS.$333.met1 0.0010666f
Cext_7400 VDD.P0.nwell VSS.$334.met1 0.0010666f
Cext_7401 VDD.P0.nwell VSS.$335.met1 0.0010666f
Cext_7402 VDD.P0.nwell VSS.$336.met1 0.0010666f
Cext_7403 VDD.P0.nwell VSS.$337.met1 0.0010666f
Cext_7404 VDD.P0.nwell VSS.$338.met1 0.0010666f
Cext_7405 VDD.P0.nwell VSS.$339.met1 0.0010666f
Cext_7406 VDD.P0.nwell VSS.$340.met1 0.0010666f
Cext_7407 VDD.P0.nwell VSS.$341.met1 0.0010666f
Cext_7408 VDD.P0.nwell VSS.$342.met1 0.0010666f
Cext_7409 VDD.P0.nwell VSS.$343.met1 0.0010666f
Cext_7410 VDD.P0.nwell VSS.$344.met1 0.0010666f
Cext_7411 VDD.P0.nwell VSS.$345.met1 0.0010666f
Cext_7412 VDD.P0.nwell VSS.$411.met2 0.00827892f
Cext_7413 VDD.P0.nwell VSS.$479.poly 0.0422381f
Cext_7414 VDD.P0.nwell VSS.$481.poly 0.0536639f
Cext_7415 VDD.P0.nwell VSS.$483.poly 0.0505886f
Cext_7416 VDD.P0.nwell VSS.$485.poly 0.0505886f
Cext_7417 VDD.P0.nwell VSS.$487.poly 0.0505886f
Cext_7418 VDD.P0.nwell VSS.$489.poly 0.0509044f
Cext_7419 VDD.P0.nwell VSS.$491.poly 0.0505886f
Cext_7420 VDD.P0.nwell VSS.$493.poly 0.0505886f
Cext_7421 VDD.P0.nwell VSS.$495.poly 0.0505886f
Cext_7422 VDD.P0.nwell VSS.$497.poly 0.0468027f
Cext_7423 VDD.P0.nwell VSS.$499.poly 0.0475515f
Cext_7424 VDD.P0.nwell VSS.$501.poly 0.050964f
Cext_7425 VDD.P0.nwell VSS.$503.poly 0.0505886f
Cext_7426 VDD.P0.nwell VSS.$505.poly 0.0505886f
Cext_7427 VDD.P0.nwell VSS.$507.poly 0.0505886f
Cext_7428 VDD.P0.nwell VSS.$509.poly 0.0505886f
Cext_7429 VDD.P0.nwell VSS.$511.poly 0.0122958f
Cext_7430 VDD.P0.nwell VSS.P0.poly 0.0075718f
Cext_7431 VREF VSS.$424.met3 0.0119047f
Cext_7432 VREF sky130_gnd 0.0344168f
Cext_7433 VREF.$0.li1 sky130_gnd 0.00435263f
Cext_7434 VREF.$100.met2 VSS.$101.li1 0.00425829f
Cext_7435 VREF.$100.met2 VSS.$103.li1 0.00477f
Cext_7436 VREF.$100.met2 VSS.$105.li1 0.00459261f
Cext_7437 VREF.$100.met2 VSS.$107.li1 0.00422242f
Cext_7438 VREF.$100.met2 VSS.$13.li1 0.00268657f
Cext_7439 VREF.$100.met2 VSS.$267.met1 0.0166383f
Cext_7440 VREF.$100.met2 VSS.$377.met2 0.0129187f
Cext_7441 VREF.$100.met2 VSS.$390.met2 0.0217391f
Cext_7442 VREF.$100.met2 VSS.$62.li1 0.0380002f
Cext_7443 VREF.$100.met2 VSS.P3.nsdm 0.00201813f
Cext_7444 VREF.$100.met2 sky130_gnd 0.473938f
Cext_7445 VREF.$101.met2 VSS.$13.li1 0.00169028f
Cext_7446 VREF.$101.met2 sky130_gnd 0.609116f
Cext_7447 VREF.$102.met2 sky130_gnd 0.0682899f
Cext_7448 VREF.$103.met2 VSS.$109.li1 0.00267107f
Cext_7449 VREF.$103.met2 VSS.$396.met2 0.0129496f
Cext_7450 VREF.$103.met2 VSS.$400.met2 0.0198779f
Cext_7451 VREF.$103.met2 VSS.$407.met2 0.00445025f
Cext_7452 VREF.$103.met2 sky130_gnd 0.16488f
Cext_7453 VREF.$104.met2 VSS.$111.li1 0.00114718f
Cext_7454 VREF.$104.met2 VSS.$113.li1 0.00131119f
Cext_7455 VREF.$104.met2 VSS.$301.met1 0.00824098f
Cext_7456 VREF.$104.met2 VSS.$302.met1 0.00662188f
Cext_7457 VREF.$104.met2 VSS.$400.met2 0.0579747f
Cext_7458 VREF.$104.met2 VSS.$405.met2 0.0053789f
Cext_7459 VREF.$104.met2 VSS.$407.met2 0.00363469f
Cext_7460 VREF.$104.met2 VSS.$424.met3 0.0576603f
Cext_7461 VREF.$104.met2 VSS.P1.nsdm 0.00203668f
Cext_7462 VREF.$104.met2 sky130_gnd 0.0451f
Cext_7463 VREF.$105.met2 sky130_gnd 0.463999f
Cext_7464 VREF.$106.met2 net1.$622.met3 0.00963914f
Cext_7465 VREF.$106.met2 sky130_gnd 0.407028f
Cext_7466 VREF.$107.met3 VSS.$267.met1 0.00197484f
Cext_7467 VREF.$107.met3 VSS.$282.met1 0.00373362f
Cext_7468 VREF.$107.met3 VSS.$285.met1 0.00326361f
Cext_7469 VREF.$107.met3 VSS.$286.met1 0.0172767f
Cext_7470 VREF.$107.met3 VSS.$287.met1 0.00307134f
Cext_7471 VREF.$107.met3 VSS.$291.met1 0.010297f
Cext_7472 VREF.$107.met3 VSS.$389.met2 0.0398554f
Cext_7473 VREF.$107.met3 VSS.$390.met2 0.0287049f
Cext_7474 VREF.$107.met3 VSS.$393.met2 0.00612119f
Cext_7475 VREF.$107.met3 VSS.$62.li1 0.0042533f
Cext_7476 VREF.$107.met3 VSS.$89.li1 0.0068569f
Cext_7477 VREF.$107.met3 VSS.P3.nsdm 0.00335182f
Cext_7478 VREF.$107.met3 sky130_gnd 0.125433f
Cext_7479 VREF.$108.met3 VSS.$115.li1 0.00133995f
Cext_7480 VREF.$108.met3 VSS.$119.li1 0.00108203f
Cext_7481 VREF.$108.met3 VSS.$309.met1 0.00103403f
Cext_7482 VREF.$108.met3 VSS.$403.met2 0.00218935f
Cext_7483 VREF.$108.met3 VSS.$406.met2 0.00258526f
Cext_7484 VREF.$108.met3 VSS.$409.met2 0.00147648f
Cext_7485 VREF.$108.met3 VSS.$424.met3 0.0143618f
Cext_7486 VREF.$108.met3 VSS.$426.met3 0.0383651f
Cext_7487 VREF.$108.met3 sky130_gnd 0.814857f
Cext_7488 VREF.$109.met3 VSS 0.00189252f
Cext_7489 VREF.$109.met3 VSS.$109.li1 0.0288073f
Cext_7490 VREF.$109.met3 VSS.$296.met1 0.00159235f
Cext_7491 VREF.$109.met3 VSS.$396.met2 0.051359f
Cext_7492 VREF.$109.met3 sky130_gnd 0.226921f
Cext_7493 VREF.$110.met3 sky130_gnd 1.3904f
Cext_7494 VREF.$111.poly VSS.$424.met3 0.00347892f
Cext_7495 VREF.$111.poly sky130_gnd 0.16689f
Cext_7496 VREF.$112.poly VSS.$400.met2 0.00100633f
Cext_7497 VREF.$112.poly VSS.$424.met3 0.00338215f
Cext_7498 VREF.$112.poly sky130_gnd 0.167706f
Cext_7499 VREF.$117.poly net2.$92.met3 0.00525828f
Cext_7500 VREF.$117.poly sky130_gnd 0.1722f
Cext_7501 VREF.$42.li1 sky130_gnd 0.00435263f
Cext_7502 VREF.$44.li1 sky130_gnd 0.0195834f
Cext_7503 VREF.$46.li1 sky130_gnd 0.01909f
Cext_7504 VREF.$48.li1 sky130_gnd 0.0140353f
Cext_7505 VREF.$50.li1 sky130_gnd 0.0140353f
Cext_7506 VREF.$52.li1 sky130_gnd 0.01957f
Cext_7507 VREF.$54.li1 sky130_gnd 0.0206882f
Cext_7508 VREF.$56.li1 sky130_gnd 0.0146524f
Cext_7509 VREF.$57.li1 sky130_gnd 0.0400424f
Cext_7510 VREF.$58.li1 sky130_gnd 0.0293049f
Cext_7511 VREF.$59.li1 sky130_gnd 0.0219786f
Cext_7512 VREF.$60.li1 sky130_gnd 0.0219786f
Cext_7513 VREF.$61.li1 sky130_gnd 0.0293049f
Cext_7514 VREF.$62.li1 sky130_gnd 0.0443271f
Cext_7515 VREF.$63.met1 sky130_gnd 0.0102344f
Cext_7516 VREF.$64.met1 sky130_gnd 0.00580037f
Cext_7517 VREF.$65.met1 sky130_gnd 0.00649879f
Cext_7518 VREF.$66.met1 sky130_gnd 0.00649879f
Cext_7519 VREF.$67.met1 sky130_gnd 0.00649879f
Cext_7520 VREF.$68.met1 sky130_gnd 0.00649879f
Cext_7521 VREF.$69.met1 sky130_gnd 0.00649879f
Cext_7522 VREF.$70.met1 sky130_gnd 0.00649879f
Cext_7523 VREF.$71.met1 sky130_gnd 0.00649879f
Cext_7524 VREF.$72.met1 sky130_gnd 0.00649879f
Cext_7525 VREF.$73.met1 sky130_gnd 0.00361044f
Cext_7526 VREF.$74.met1 sky130_gnd 0.00361044f
Cext_7527 VREF.$75.met1 sky130_gnd 0.00649879f
Cext_7528 VREF.$76.met1 sky130_gnd 0.00649879f
Cext_7529 VREF.$77.met1 sky130_gnd 0.00649879f
Cext_7530 VREF.$78.met1 sky130_gnd 0.00649879f
Cext_7531 VREF.$79.met1 sky130_gnd 0.00649879f
Cext_7532 VREF.$80.met1 sky130_gnd 0.00649879f
Cext_7533 VREF.$81.met1 sky130_gnd 0.00649879f
Cext_7534 VREF.$82.met1 sky130_gnd 0.00649879f
Cext_7535 VREF.$83.met1 sky130_gnd 0.00649879f
Cext_7536 VREF.$84.met1 sky130_gnd 0.0124752f
Cext_7537 VREF.$85.met1 sky130_gnd 0.00569622f
Cext_7538 VREF.$86.met1 VSS.$424.met3 0.00163805f
Cext_7539 VREF.$86.met1 sky130_gnd 0.0180781f
Cext_7540 VREF.$87.met1 VSS 0.00283289f
Cext_7541 VREF.$87.met1 VSS.$400.met2 0.00172077f
Cext_7542 VREF.$87.met1 VSS.$424.met3 0.00113553f
Cext_7543 VREF.$87.met1 sky130_gnd 0.0193267f
Cext_7544 VREF.$88.met1 sky130_gnd 0.016587f
Cext_7545 VREF.$89.met1 sky130_gnd 0.007656f
Cext_7546 VREF.$90.met1 sky130_gnd 0.0143234f
Cext_7547 VREF.$91.met1 VSS.$424.met3 0.00176153f
Cext_7548 VREF.$91.met1 VSS.$426.met3 0.00112919f
Cext_7549 VREF.$91.met1 sky130_gnd 0.0201047f
Cext_7550 VREF.$92.met1 VSS.$424.met3 0.0013515f
Cext_7551 VREF.$92.met1 sky130_gnd 0.0222207f
Cext_7552 VREF.$93.met1 sky130_gnd 0.037835f
Cext_7553 VREF.$95.met1 sky130_gnd 0.028336f
Cext_7554 VREF.$96.met1 sky130_gnd 0.0286468f
Cext_7555 VREF.$97.met1 sky130_gnd 0.0286468f
Cext_7556 VREF.$98.met1 sky130_gnd 0.0286468f
Cext_7557 VREF.$99.met1 sky130_gnd 0.0367023f
Cext_7558 VREF.P0.poly VSS.$111.li1 0.014808f
Cext_7559 VREF.P0.poly VSS.$113.li1 0.0141733f
Cext_7560 VREF.P0.poly VSS.$115.li1 0.00233022f
Cext_7561 VREF.P0.poly VSS.$301.met1 0.00762256f
Cext_7562 VREF.P0.poly VSS.$302.met1 0.00766946f
Cext_7563 VREF.P0.poly VSS.$403.met2 0.00151087f
Cext_7564 VREF.P0.poly VSS.$424.met3 0.0047962f
Cext_7565 VREF.P0.poly VSS.$426.met3 0.00117037f
Cext_7566 VREF.P1.poly sky130_gnd 0.174903f
Cext_7567 VSS sky130_gnd 0.0788183f
Cext_7568 VSS.$0.li1 net1 0.0477765f
Cext_7569 VSS.$0.li1 net1.$295.met1 0.00153968f
Cext_7570 VSS.$0.li1 net1.$298.met1 0.03679f
Cext_7571 VSS.$0.li1 net1.$316.met1 0.00193003f
Cext_7572 VSS.$0.li1 net1.$598.met2 0.00248954f
Cext_7573 VSS.$0.li1 net1.$600.met2 0.0400383f
Cext_7574 VSS.$0.li1 net1.$616.met3 0.00333587f
Cext_7575 VSS.$0.li1 net1.P0.li1 0.089877f
Cext_7576 VSS.$0.li1 sky130_gnd 0.528739f
Cext_7577 VSS.$1.li1 net1.$297.met1 0.00740911f
Cext_7578 VSS.$1.li1 net1.$310.met1 0.0325099f
Cext_7579 VSS.$1.li1 net1.$328.met1 0.00657773f
Cext_7580 VSS.$1.li1 net1.$346.met1 0.0030311f
Cext_7581 VSS.$1.li1 net1.$601.met2 0.0721245f
Cext_7582 VSS.$1.li1 net1.P261.li1 0.11237f
Cext_7583 VSS.$1.li1 sky130_gnd 0.510361f
Cext_7584 VSS.$10.li1 net1 0.00371478f
Cext_7585 VSS.$10.li1 net1.$388.met1 0.00655305f
Cext_7586 VSS.$10.li1 net1.$406.met1 0.00150108f
Cext_7587 VSS.$10.li1 net1.$408.met1 0.0363551f
Cext_7588 VSS.$10.li1 net1.$420.met1 0.00467302f
Cext_7589 VSS.$10.li1 net1.$432.met1 0.00341735f
Cext_7590 VSS.$10.li1 net1.$602.met2 0.0023431f
Cext_7591 VSS.$10.li1 net1.$617.met3 0.0548314f
Cext_7592 VSS.$10.li1 net1.$618.met3 0.00114954f
Cext_7593 VSS.$10.li1 net1.P609.li1 0.10346f
Cext_7594 VSS.$10.li1 sky130_gnd 0.28668f
Cext_7595 VSS.$100.li1 sky130_gnd 0.0108138f
Cext_7596 VSS.$101.li1 sky130_gnd 0.0203285f
Cext_7597 VSS.$103.li1 sky130_gnd 0.0203285f
Cext_7598 VSS.$105.li1 sky130_gnd 0.0203285f
Cext_7599 VSS.$107.li1 sky130_gnd 0.0329189f
Cext_7600 VSS.$109.li1 sky130_gnd 0.297455f
Cext_7601 VSS.$11.li1 net1.$394.met1 0.00202874f
Cext_7602 VSS.$11.li1 net1.$604.met2 0.00282728f
Cext_7603 VSS.$11.li1 net1.$617.met3 0.00468665f
Cext_7604 VSS.$11.li1 net1.$618.met3 0.0163286f
Cext_7605 VSS.$11.li1 sky130_gnd 0.37246f
Cext_7606 VSS.$110.li1 net2 0.0140704f
Cext_7607 VSS.$110.li1 net2.$43.met1 0.00740911f
Cext_7608 VSS.$110.li1 net2.$44.met1 0.0146306f
Cext_7609 VSS.$110.li1 net2.$50.met1 0.00657773f
Cext_7610 VSS.$110.li1 net2.$56.met1 0.00657773f
Cext_7611 VSS.$110.li1 net2.$62.met1 0.00657773f
Cext_7612 VSS.$110.li1 net2.$68.met1 0.00338216f
Cext_7613 VSS.$110.li1 net2.$87.met2 0.00605914f
Cext_7614 VSS.$110.li1 net2.P0.li1 0.108704f
Cext_7615 VSS.$110.li1 sky130_gnd 0.452526f
Cext_7616 VSS.$111.li1 sky130_gnd 0.0355709f
Cext_7617 VSS.$113.li1 sky130_gnd 0.0435478f
Cext_7618 VSS.$115.li1 sky130_gnd 0.085953f
Cext_7619 VSS.$116.li1 net2 0.00421352f
Cext_7620 VSS.$116.li1 net2.$68.met1 0.00319557f
Cext_7621 VSS.$116.li1 net2.$74.met1 0.0284661f
Cext_7622 VSS.$116.li1 net2.P0.li1 0.0665135f
Cext_7623 VSS.$116.li1 sky130_gnd 0.41884f
Cext_7624 VSS.$117.li1 sky130_gnd 0.0231959f
Cext_7625 VSS.$119.li1 sky130_gnd 0.0802077f
Cext_7626 VSS.$12.li1 net1.$400.met1 0.00739693f
Cext_7627 VSS.$12.li1 net1.$407.met1 0.0074001f
Cext_7628 VSS.$12.li1 net1.$414.met1 0.0264334f
Cext_7629 VSS.$12.li1 net1.$426.met1 0.00657773f
Cext_7630 VSS.$12.li1 net1.$438.met1 0.00456269f
Cext_7631 VSS.$12.li1 net1.$605.met2 0.0496759f
Cext_7632 VSS.$12.li1 net1.$618.met3 0.00144404f
Cext_7633 VSS.$12.li1 net1.P174.li1 0.109563f
Cext_7634 VSS.$12.li1 sky130_gnd 0.513464f
Cext_7635 VSS.$120.li1 sky130_gnd 0.0152563f
Cext_7636 VSS.$122.li1 sky130_gnd 0.0152563f
Cext_7637 VSS.$124.li1 sky130_gnd 0.0125941f
Cext_7638 VSS.$126.li1 sky130_gnd 0.0125941f
Cext_7639 VSS.$128.li1 sky130_gnd 0.0125941f
Cext_7640 VSS.$13.li1 sky130_gnd 0.411086f
Cext_7641 VSS.$130.li1 sky130_gnd 0.0125941f
Cext_7642 VSS.$132.li1 sky130_gnd 0.0125941f
Cext_7643 VSS.$134.li1 sky130_gnd 0.0125941f
Cext_7644 VSS.$136.li1 sky130_gnd 0.0125941f
Cext_7645 VSS.$138.li1 sky130_gnd 0.0125941f
Cext_7646 VSS.$14.li1 sky130_gnd 0.0316681f
Cext_7647 VSS.$140.li1 sky130_gnd 0.0125941f
Cext_7648 VSS.$142.li1 sky130_gnd 0.0125941f
Cext_7649 VSS.$144.li1 sky130_gnd 0.0125941f
Cext_7650 VSS.$146.li1 sky130_gnd 0.0125941f
Cext_7651 VSS.$148.li1 sky130_gnd 0.0125941f
Cext_7652 VSS.$150.li1 sky130_gnd 0.0125941f
Cext_7653 VSS.$152.li1 sky130_gnd 0.0125941f
Cext_7654 VSS.$154.li1 sky130_gnd 0.0125941f
Cext_7655 VSS.$156.li1 sky130_gnd 0.0125941f
Cext_7656 VSS.$158.li1 sky130_gnd 0.0125941f
Cext_7657 VSS.$16.li1 sky130_gnd 0.0203285f
Cext_7658 VSS.$160.li1 sky130_gnd 0.0125941f
Cext_7659 VSS.$162.li1 sky130_gnd 0.0125941f
Cext_7660 VSS.$164.li1 sky130_gnd 0.0125941f
Cext_7661 VSS.$166.li1 sky130_gnd 0.0125941f
Cext_7662 VSS.$168.li1 sky130_gnd 0.0125941f
Cext_7663 VSS.$170.li1 sky130_gnd 0.0125941f
Cext_7664 VSS.$172.li1 sky130_gnd 0.0125941f
Cext_7665 VSS.$174.li1 sky130_gnd 0.0125941f
Cext_7666 VSS.$176.li1 sky130_gnd 0.0125941f
Cext_7667 VSS.$178.li1 sky130_gnd 0.0125941f
Cext_7668 VSS.$18.li1 sky130_gnd 0.0203285f
Cext_7669 VSS.$180.li1 sky130_gnd 0.0125941f
Cext_7670 VSS.$182.li1 sky130_gnd 0.0125941f
Cext_7671 VSS.$184.li1 sky130_gnd 0.0125941f
Cext_7672 VSS.$186.li1 sky130_gnd 0.0125941f
Cext_7673 VSS.$188.li1 sky130_gnd 0.0125941f
Cext_7674 VSS.$190.li1 sky130_gnd 0.0125941f
Cext_7675 VSS.$192.li1 sky130_gnd 0.0125941f
Cext_7676 VSS.$194.li1 sky130_gnd 0.0125941f
Cext_7677 VSS.$196.li1 sky130_gnd 0.0125941f
Cext_7678 VSS.$198.li1 sky130_gnd 0.0125941f
Cext_7679 VSS.$2.li1 net1 0.016486f
Cext_7680 VSS.$2.li1 net1.$296.met1 0.00136876f
Cext_7681 VSS.$2.li1 net1.$316.met1 0.0046477f
Cext_7682 VSS.$2.li1 net1.$334.met1 0.00657773f
Cext_7683 VSS.$2.li1 net1.$352.met1 0.00657773f
Cext_7684 VSS.$2.li1 net1.$370.met1 0.00520634f
Cext_7685 VSS.$2.li1 net1.$388.met1 0.0130665f
Cext_7686 VSS.$2.li1 net1.$600.met2 0.0256566f
Cext_7687 VSS.$2.li1 net1.$616.met3 0.00824908f
Cext_7688 VSS.$2.li1 net1.$617.met3 0.00685492f
Cext_7689 VSS.$2.li1 net1.P0.li1 0.0937286f
Cext_7690 VSS.$2.li1 sky130_gnd 0.297347f
Cext_7691 VSS.$20.li1 sky130_gnd 0.0203285f
Cext_7692 VSS.$200.li1 sky130_gnd 0.0125941f
Cext_7693 VSS.$202.li1 sky130_gnd 0.0125941f
Cext_7694 VSS.$204.li1 sky130_gnd 0.0157326f
Cext_7695 VSS.$206.li1 sky130_gnd 0.0157326f
Cext_7696 VSS.$208.met1 net1 0.00163564f
Cext_7697 VSS.$208.met1 net1.$298.met1 0.00136723f
Cext_7698 VSS.$208.met1 net1.P0.li1 0.0060972f
Cext_7699 VSS.$208.met1 sky130_gnd 0.0164423f
Cext_7700 VSS.$209.met1 net1.$297.met1 0.00806004f
Cext_7701 VSS.$209.met1 net1.P261.li1 0.00230162f
Cext_7702 VSS.$209.met1 sky130_gnd 0.0156558f
Cext_7703 VSS.$212.met1 net1.$370.met1 0.00510145f
Cext_7704 VSS.$212.met1 net1.$376.met1 0.00187733f
Cext_7705 VSS.$212.met1 sky130_gnd 0.0156814f
Cext_7706 VSS.$213.met1 net1.$376.met1 0.00510145f
Cext_7707 VSS.$213.met1 net1.$382.met1 0.00187733f
Cext_7708 VSS.$213.met1 sky130_gnd 0.0156814f
Cext_7709 VSS.$214.met1 net1.$382.met1 0.00510145f
Cext_7710 VSS.$214.met1 sky130_gnd 0.0210825f
Cext_7711 VSS.$218.met1 net1.$394.met1 0.00136723f
Cext_7712 VSS.$218.met1 net1.P435.li1 0.0060972f
Cext_7713 VSS.$218.met1 sky130_gnd 0.01208f
Cext_7714 VSS.$22.li1 sky130_gnd 0.0203285f
Cext_7715 VSS.$220.met1 sky130_gnd 0.033544f
Cext_7716 VSS.$222.met1 sky130_gnd 0.0160373f
Cext_7717 VSS.$223.met1 net1.$604.met2 0.00191451f
Cext_7718 VSS.$223.met1 sky130_gnd 0.0160373f
Cext_7719 VSS.$224.met1 sky130_gnd 0.0215177f
Cext_7720 VSS.$228.met1 net1.$408.met1 0.00136723f
Cext_7721 VSS.$228.met1 net1.P609.li1 0.0060972f
Cext_7722 VSS.$228.met1 sky130_gnd 0.00824151f
Cext_7723 VSS.$229.met1 net1.$394.met1 0.00163251f
Cext_7724 VSS.$229.met1 sky130_gnd 0.00924014f
Cext_7725 VSS.$230.met1 net1.$400.met1 0.00163251f
Cext_7726 VSS.$230.met1 net1.$407.met1 0.00806004f
Cext_7727 VSS.$230.met1 net1.P174.li1 0.00230162f
Cext_7728 VSS.$230.met1 sky130_gnd 0.00924014f
Cext_7729 VSS.$234.met1 sky130_gnd 0.0342707f
Cext_7730 VSS.$236.met1 sky130_gnd 0.0174587f
Cext_7731 VSS.$237.met1 sky130_gnd 0.00930211f
Cext_7732 VSS.$238.met1 sky130_gnd 0.00930211f
Cext_7733 VSS.$239.met1 sky130_gnd 0.00930211f
Cext_7734 VSS.$24.li1 sky130_gnd 0.0203285f
Cext_7735 VSS.$240.met1 sky130_gnd 0.00930211f
Cext_7736 VSS.$241.met1 sky130_gnd 0.00930211f
Cext_7737 VSS.$242.met1 sky130_gnd 0.00930211f
Cext_7738 VSS.$243.met1 sky130_gnd 0.00930211f
Cext_7739 VSS.$244.met1 sky130_gnd 0.00930211f
Cext_7740 VSS.$245.met1 sky130_gnd 0.00930211f
Cext_7741 VSS.$246.met1 sky130_gnd 0.00930211f
Cext_7742 VSS.$247.met1 sky130_gnd 0.00930211f
Cext_7743 VSS.$248.met1 sky130_gnd 0.00930211f
Cext_7744 VSS.$249.met1 sky130_gnd 0.00930211f
Cext_7745 VSS.$250.met1 sky130_gnd 0.00930211f
Cext_7746 VSS.$251.met1 sky130_gnd 0.00930211f
Cext_7747 VSS.$252.met1 sky130_gnd 0.00930211f
Cext_7748 VSS.$253.met1 sky130_gnd 0.00930211f
Cext_7749 VSS.$254.met1 sky130_gnd 0.00930211f
Cext_7750 VSS.$255.met1 sky130_gnd 0.00930211f
Cext_7751 VSS.$256.met1 sky130_gnd 0.00930211f
Cext_7752 VSS.$257.met1 sky130_gnd 0.0171582f
Cext_7753 VSS.$258.met1 sky130_gnd 0.00119546f
Cext_7754 VSS.$259.met1 net1.$612.met2 0.00191451f
Cext_7755 VSS.$259.met1 sky130_gnd 0.0221605f
Cext_7756 VSS.$26.li1 sky130_gnd 0.0203285f
Cext_7757 VSS.$261.met1 net1.$474.met1 0.00163251f
Cext_7758 VSS.$261.met1 net1.$482.met1 0.00804429f
Cext_7759 VSS.$261.met1 net1.P100.li1 0.00230162f
Cext_7760 VSS.$261.met1 sky130_gnd 0.00937536f
Cext_7761 VSS.$263.met1 net1.$480.met1 0.00806004f
Cext_7762 VSS.$263.met1 net1.P522.li1 0.00230162f
Cext_7763 VSS.$263.met1 sky130_gnd 0.0156558f
Cext_7764 VSS.$264.met1 net1.$481.met1 0.00804429f
Cext_7765 VSS.$264.met1 net1.$483.met1 0.00163251f
Cext_7766 VSS.$264.met1 net1.$607.met2 0.00193442f
Cext_7767 VSS.$264.met1 net1.P348.li1 0.00230162f
Cext_7768 VSS.$264.met1 sky130_gnd 0.00937536f
Cext_7769 VSS.$267.met1 sky130_gnd 0.033544f
Cext_7770 VSS.$269.met1 sky130_gnd 0.0224463f
Cext_7771 VSS.$270.met1 net1.$573.met1 0.00510145f
Cext_7772 VSS.$270.met1 sky130_gnd 0.0210825f
Cext_7773 VSS.$271.met1 sky130_gnd 0.0192425f
Cext_7774 VSS.$274.met1 sky130_gnd 0.0169128f
Cext_7775 VSS.$276.met1 sky130_gnd 0.00889859f
Cext_7776 VSS.$277.met1 sky130_gnd 0.00930211f
Cext_7777 VSS.$278.met1 sky130_gnd 0.00930211f
Cext_7778 VSS.$279.met1 sky130_gnd 0.00930211f
Cext_7779 VSS.$28.li1 sky130_gnd 0.0203285f
Cext_7780 VSS.$280.met1 sky130_gnd 0.00930211f
Cext_7781 VSS.$281.met1 sky130_gnd 0.00930211f
Cext_7782 VSS.$282.met1 sky130_gnd 0.00930211f
Cext_7783 VSS.$283.met1 sky130_gnd 0.00930211f
Cext_7784 VSS.$284.met1 sky130_gnd 0.00873659f
Cext_7785 VSS.$285.met1 sky130_gnd 0.00873659f
Cext_7786 VSS.$286.met1 sky130_gnd 0.00930211f
Cext_7787 VSS.$287.met1 sky130_gnd 0.00930211f
Cext_7788 VSS.$288.met1 sky130_gnd 0.00930211f
Cext_7789 VSS.$289.met1 sky130_gnd 0.00930211f
Cext_7790 VSS.$290.met1 sky130_gnd 0.00930211f
Cext_7791 VSS.$291.met1 sky130_gnd 0.00930211f
Cext_7792 VSS.$292.met1 sky130_gnd 0.00930211f
Cext_7793 VSS.$293.met1 sky130_gnd 0.00930211f
Cext_7794 VSS.$294.met1 sky130_gnd 0.00930211f
Cext_7795 VSS.$295.met1 sky130_gnd 0.0174587f
Cext_7796 VSS.$296.met1 sky130_gnd 0.0393085f
Cext_7797 VSS.$298.met1 net2.$43.met1 0.00845139f
Cext_7798 VSS.$298.met1 net2.P0.li1 0.00230162f
Cext_7799 VSS.$298.met1 sky130_gnd 0.0155027f
Cext_7800 VSS.$3.li1 net1.$304.met1 0.00644617f
Cext_7801 VSS.$3.li1 net1.$322.met1 0.00657773f
Cext_7802 VSS.$3.li1 net1.$340.met1 0.0068544f
Cext_7803 VSS.$3.li1 net1.$346.met1 0.0020443f
Cext_7804 VSS.$3.li1 net1.$358.met1 0.00691042f
Cext_7805 VSS.$3.li1 net1.$364.met1 0.00240204f
Cext_7806 VSS.$3.li1 net1.$376.met1 0.00527493f
Cext_7807 VSS.$3.li1 net1.$382.met1 0.00197116f
Cext_7808 VSS.$3.li1 net1.$394.met1 0.0157992f
Cext_7809 VSS.$3.li1 net1.$400.met1 0.00263061f
Cext_7810 VSS.$3.li1 net1.$600.met2 0.0329573f
Cext_7811 VSS.$3.li1 net1.$601.met2 0.0516254f
Cext_7812 VSS.$3.li1 net1.P435.li1 0.119496f
Cext_7813 VSS.$3.li1 sky130_gnd 0.561707f
Cext_7814 VSS.$30.li1 sky130_gnd 0.0203285f
Cext_7815 VSS.$300.met1 sky130_gnd 0.019736f
Cext_7816 VSS.$301.met1 sky130_gnd 0.0154005f
Cext_7817 VSS.$302.met1 sky130_gnd 0.0125322f
Cext_7818 VSS.$303.met1 sky130_gnd 0.0358562f
Cext_7819 VSS.$305.met1 sky130_gnd 0.0259284f
Cext_7820 VSS.$307.met1 sky130_gnd 0.0210006f
Cext_7821 VSS.$308.met1 sky130_gnd 0.0106599f
Cext_7822 VSS.$309.met1 sky130_gnd 0.0394504f
Cext_7823 VSS.$311.met1 sky130_gnd 0.0162181f
Cext_7824 VSS.$312.met1 sky130_gnd 0.0162181f
Cext_7825 VSS.$313.met1 sky130_gnd 0.00860658f
Cext_7826 VSS.$314.met1 sky130_gnd 0.0132568f
Cext_7827 VSS.$315.met1 sky130_gnd 0.0141672f
Cext_7828 VSS.$316.met1 sky130_gnd 0.00681253f
Cext_7829 VSS.$317.met1 sky130_gnd 0.0132568f
Cext_7830 VSS.$318.met1 sky130_gnd 0.0132568f
Cext_7831 VSS.$319.met1 sky130_gnd 0.0132568f
Cext_7832 VSS.$32.li1 sky130_gnd 0.0203285f
Cext_7833 VSS.$320.met1 sky130_gnd 0.0132568f
Cext_7834 VSS.$321.met1 sky130_gnd 0.0132568f
Cext_7835 VSS.$322.met1 sky130_gnd 0.0132568f
Cext_7836 VSS.$323.met1 sky130_gnd 0.0132568f
Cext_7837 VSS.$324.met1 sky130_gnd 0.0132568f
Cext_7838 VSS.$325.met1 sky130_gnd 0.0132568f
Cext_7839 VSS.$326.met1 sky130_gnd 0.0132568f
Cext_7840 VSS.$327.met1 sky130_gnd 0.0132568f
Cext_7841 VSS.$328.met1 sky130_gnd 0.0132568f
Cext_7842 VSS.$329.met1 sky130_gnd 0.0132568f
Cext_7843 VSS.$330.met1 sky130_gnd 0.0132568f
Cext_7844 VSS.$331.met1 sky130_gnd 0.0132568f
Cext_7845 VSS.$332.met1 sky130_gnd 0.0132568f
Cext_7846 VSS.$333.met1 sky130_gnd 0.0132568f
Cext_7847 VSS.$334.met1 sky130_gnd 0.0132568f
Cext_7848 VSS.$335.met1 sky130_gnd 0.0132568f
Cext_7849 VSS.$336.met1 sky130_gnd 0.0132568f
Cext_7850 VSS.$337.met1 sky130_gnd 0.0132568f
Cext_7851 VSS.$338.met1 sky130_gnd 0.0132568f
Cext_7852 VSS.$339.met1 sky130_gnd 0.0132568f
Cext_7853 VSS.$34.li1 sky130_gnd 0.0203285f
Cext_7854 VSS.$340.met1 sky130_gnd 0.0132568f
Cext_7855 VSS.$341.met1 sky130_gnd 0.0132568f
Cext_7856 VSS.$342.met1 sky130_gnd 0.0132568f
Cext_7857 VSS.$343.met1 sky130_gnd 0.0132568f
Cext_7858 VSS.$344.met1 sky130_gnd 0.0132568f
Cext_7859 VSS.$345.met1 sky130_gnd 0.0132568f
Cext_7860 VSS.$346.met1 sky130_gnd 0.0132568f
Cext_7861 VSS.$347.met1 sky130_gnd 0.0132568f
Cext_7862 VSS.$348.met1 sky130_gnd 0.0132568f
Cext_7863 VSS.$349.met1 sky130_gnd 0.0132568f
Cext_7864 VSS.$350.met1 sky130_gnd 0.0132568f
Cext_7865 VSS.$351.met1 sky130_gnd 0.0132568f
Cext_7866 VSS.$352.met1 sky130_gnd 0.0132568f
Cext_7867 VSS.$353.met1 sky130_gnd 0.0132568f
Cext_7868 VSS.$354.met1 sky130_gnd 0.0177703f
Cext_7869 VSS.$355.met1 sky130_gnd 0.0177703f
Cext_7870 VSS.$356.met2 net1 0.013652f
Cext_7871 VSS.$356.met2 net1.$600.met2 0.0059191f
Cext_7872 VSS.$356.met2 sky130_gnd 0.0308556f
Cext_7873 VSS.$357.met2 net1 0.0202757f
Cext_7874 VSS.$357.met2 net1.P0.li1 0.00123527f
Cext_7875 VSS.$357.met2 sky130_gnd 0.0258623f
Cext_7876 VSS.$358.met2 net1.$310.met1 0.082945f
Cext_7877 VSS.$358.met2 net1.$328.met1 0.0104524f
Cext_7878 VSS.$358.met2 net1.$601.met2 0.0242316f
Cext_7879 VSS.$358.met2 net1.P261.li1 0.0207632f
Cext_7880 VSS.$358.met2 sky130_gnd 0.0718811f
Cext_7881 VSS.$359.met2 net1.$310.met1 0.0150491f
Cext_7882 VSS.$359.met2 net1.$328.met1 0.201054f
Cext_7883 VSS.$359.met2 net1.$346.met1 0.105131f
Cext_7884 VSS.$359.met2 net1.$364.met1 0.0865956f
Cext_7885 VSS.$359.met2 net1.$382.met1 0.13749f
Cext_7886 VSS.$359.met2 net1.$400.met1 0.126043f
Cext_7887 VSS.$359.met2 net1.$601.met2 0.0213458f
Cext_7888 VSS.$359.met2 net1.P261.li1 0.0351095f
Cext_7889 VSS.$359.met2 sky130_gnd 0.0862595f
Cext_7890 VSS.$36.li1 sky130_gnd 0.0203285f
Cext_7891 VSS.$360.met2 net1 0.00247587f
Cext_7892 VSS.$360.met2 net1.$370.met1 0.00575773f
Cext_7893 VSS.$360.met2 net1.$600.met2 0.00148944f
Cext_7894 VSS.$360.met2 net1.P0.li1 0.00176996f
Cext_7895 VSS.$360.met2 sky130_gnd 0.0090099f
Cext_7896 VSS.$361.met2 net1.$328.met1 0.022424f
Cext_7897 VSS.$361.met2 net1.$364.met1 0.00136907f
Cext_7898 VSS.$361.met2 net1.$382.met1 0.0352731f
Cext_7899 VSS.$361.met2 net1.$400.met1 0.0185128f
Cext_7900 VSS.$361.met2 net1.P261.li1 0.0176971f
Cext_7901 VSS.$361.met2 sky130_gnd 0.037175f
Cext_7902 VSS.$362.met2 net1.$376.met1 0.00298311f
Cext_7903 VSS.$362.met2 net1.$600.met2 0.0235301f
Cext_7904 VSS.$362.met2 sky130_gnd 0.0676344f
Cext_7905 VSS.$363.met2 net1.$358.met1 0.0770257f
Cext_7906 VSS.$363.met2 net1.$376.met1 0.00801254f
Cext_7907 VSS.$363.met2 net1.$382.met1 0.018021f
Cext_7908 VSS.$363.met2 net1.$394.met1 0.0497453f
Cext_7909 VSS.$363.met2 net1.$400.met1 0.00130795f
Cext_7910 VSS.$363.met2 net1.$600.met2 0.0207996f
Cext_7911 VSS.$363.met2 net1.$601.met2 0.0342463f
Cext_7912 VSS.$363.met2 net1.P261.li1 0.00157425f
Cext_7913 VSS.$363.met2 net1.P435.li1 0.0259898f
Cext_7914 VSS.$363.met2 sky130_gnd 0.142901f
Cext_7915 VSS.$364.met2 sky130_gnd 0.0198748f
Cext_7916 VSS.$365.met2 net1.$376.met1 0.00177202f
Cext_7917 VSS.$365.met2 net1.P0.li1 0.00111214f
Cext_7918 VSS.$365.met2 sky130_gnd 0.0209871f
Cext_7919 VSS.$366.met2 sky130_gnd 0.00899296f
Cext_7920 VSS.$367.met2 net1.$358.met1 0.116521f
Cext_7921 VSS.$367.met2 net1.$376.met1 0.0107554f
Cext_7922 VSS.$367.met2 net1.$388.met1 0.00105331f
Cext_7923 VSS.$367.met2 net1.$394.met1 0.0772414f
Cext_7924 VSS.$367.met2 net1.$600.met2 0.0391542f
Cext_7925 VSS.$367.met2 net1.P435.li1 0.0328371f
Cext_7926 VSS.$367.met2 sky130_gnd 0.0624814f
Cext_7927 VSS.$368.met2 sky130_gnd 0.0424887f
Cext_7928 VSS.$369.met2 net1.$414.met1 0.0173201f
Cext_7929 VSS.$369.met2 net1.P174.li1 0.00795015f
Cext_7930 VSS.$369.met2 sky130_gnd 0.0363163f
Cext_7931 VSS.$370.met2 net1.$607.met2 0.00680627f
Cext_7932 VSS.$370.met2 net1.$608.met2 0.00109921f
Cext_7933 VSS.$370.met2 net1.$617.met3 0.0027821f
Cext_7934 VSS.$370.met2 sky130_gnd 0.137006f
Cext_7935 VSS.$371.met2 net1.$604.met2 0.0675054f
Cext_7936 VSS.$371.met2 net1.$605.met2 0.0440271f
Cext_7937 VSS.$371.met2 sky130_gnd 0.106876f
Cext_7938 VSS.$372.met2 sky130_gnd 0.0184468f
Cext_7939 VSS.$373.met2 net1 0.00286117f
Cext_7940 VSS.$373.met2 net1.$444.met1 0.00191606f
Cext_7941 VSS.$373.met2 net1.$608.met2 0.00252009f
Cext_7942 VSS.$373.met2 net1.P0.li1 0.00100271f
Cext_7943 VSS.$373.met2 net1.P609.li1 0.00704802f
Cext_7944 VSS.$373.met2 sky130_gnd 0.0173484f
Cext_7945 VSS.$374.met2 net1.$604.met2 0.0353649f
Cext_7946 VSS.$374.met2 net1.$607.met2 0.00538987f
Cext_7947 VSS.$374.met2 net1.$618.met3 0.0071207f
Cext_7948 VSS.$374.met2 sky130_gnd 0.0759215f
Cext_7949 VSS.$375.met2 net1.$400.met1 0.00177315f
Cext_7950 VSS.$375.met2 net1.$414.met1 0.0349966f
Cext_7951 VSS.$375.met2 net1.$605.met2 0.0609499f
Cext_7952 VSS.$375.met2 net1.P174.li1 0.0100302f
Cext_7953 VSS.$375.met2 net1.P261.li1 0.00150925f
Cext_7954 VSS.$375.met2 sky130_gnd 0.064218f
Cext_7955 VSS.$376.met2 sky130_gnd 0.0308178f
Cext_7956 VSS.$377.met2 sky130_gnd 0.114256f
Cext_7957 VSS.$378.met2 sky130_gnd 0.0071418f
Cext_7958 VSS.$379.met2 sky130_gnd 0.212791f
Cext_7959 VSS.$38.li1 sky130_gnd 0.0203285f
Cext_7960 VSS.$380.met2 sky130_gnd 0.974991f
Cext_7961 VSS.$381.met2 net1.$462.met1 0.00256262f
Cext_7962 VSS.$381.met2 net1.$495.met1 0.0106794f
Cext_7963 VSS.$381.met2 net1.$612.met2 0.0490983f
Cext_7964 VSS.$381.met2 net1.P100.li1 0.00691516f
Cext_7965 VSS.$381.met2 net1.P174.li1 0.00128662f
Cext_7966 VSS.$381.met2 sky130_gnd 0.0348454f
Cext_7967 VSS.$382.met2 net1.$462.met1 0.00108849f
Cext_7968 VSS.$382.met2 net1.$495.met1 0.005235f
Cext_7969 VSS.$382.met2 net1.$612.met2 0.0576889f
Cext_7970 VSS.$382.met2 net1.P100.li1 0.00433071f
Cext_7971 VSS.$382.met2 net1.P174.li1 0.00125755f
Cext_7972 VSS.$382.met2 sky130_gnd 0.0352989f
Cext_7973 VSS.$383.met2 net1.$612.met2 0.0952579f
Cext_7974 VSS.$383.met2 net1.$613.met2 0.214227f
Cext_7975 VSS.$383.met2 net1.$621.met3 0.0072428f
Cext_7976 VSS.$383.met2 sky130_gnd 0.648191f
Cext_7977 VSS.$384.met2 net1.$606.met2 0.00118096f
Cext_7978 VSS.$384.met2 net1.$612.met2 0.0145909f
Cext_7979 VSS.$384.met2 net1.P100.li1 0.00159096f
Cext_7980 VSS.$384.met2 sky130_gnd 0.00416826f
Cext_7981 VSS.$385.met2 net1.$483.met1 0.115249f
Cext_7982 VSS.$385.met2 net1.$501.met1 0.0348574f
Cext_7983 VSS.$385.met2 net1.$519.met1 0.128549f
Cext_7984 VSS.$385.met2 net1.$555.met1 0.114439f
Cext_7985 VSS.$385.met2 net1.$608.met2 0.0253741f
Cext_7986 VSS.$385.met2 net1.$609.met2 0.0147698f
Cext_7987 VSS.$385.met2 net1.$610.met2 0.0118056f
Cext_7988 VSS.$385.met2 net1.$620.met3 0.0142306f
Cext_7989 VSS.$385.met2 net1.P522.li1 0.0303335f
Cext_7990 VSS.$385.met2 sky130_gnd 0.0920124f
Cext_7991 VSS.$386.met2 net1.$489.met1 0.00281108f
Cext_7992 VSS.$386.met2 net1.$507.met1 0.00451635f
Cext_7993 VSS.$386.met2 net1.$607.met2 0.0122159f
Cext_7994 VSS.$386.met2 net1.$611.met2 0.0139534f
Cext_7995 VSS.$386.met2 net1.P348.li1 0.00282089f
Cext_7996 VSS.$386.met2 sky130_gnd 0.0114575f
Cext_7997 VSS.$387.met2 net1.$501.met1 0.00137076f
Cext_7998 VSS.$387.met2 net1.$507.met1 0.151771f
Cext_7999 VSS.$387.met2 net1.$519.met1 0.0184454f
Cext_8000 VSS.$387.met2 net1.$525.met1 0.179145f
Cext_8001 VSS.$387.met2 net1.$537.met1 0.00104818f
Cext_8002 VSS.$387.met2 net1.$543.met1 0.0126123f
Cext_8003 VSS.$387.met2 net1.$555.met1 0.00104818f
Cext_8004 VSS.$387.met2 net1.$561.met1 0.194836f
Cext_8005 VSS.$387.met2 net1.$579.met1 0.00466654f
Cext_8006 VSS.$387.met2 net1.$606.met2 0.069328f
Cext_8007 VSS.$387.met2 net1.$607.met2 0.0469903f
Cext_8008 VSS.$387.met2 net1.$608.met2 0.00770339f
Cext_8009 VSS.$387.met2 net1.$611.met2 0.0389077f
Cext_8010 VSS.$387.met2 net1.$619.met3 0.00160759f
Cext_8011 VSS.$387.met2 net1.P348.li1 0.0436425f
Cext_8012 VSS.$387.met2 net1.P522.li1 0.00114f
Cext_8013 VSS.$387.met2 sky130_gnd 0.159432f
Cext_8014 VSS.$388.met2 net1.$513.met1 0.0191346f
Cext_8015 VSS.$388.met2 net1.$525.met1 0.0182043f
Cext_8016 VSS.$388.met2 net1.$531.met1 0.061785f
Cext_8017 VSS.$388.met2 net1.$567.met1 0.0222938f
Cext_8018 VSS.$388.met2 net1.$606.met2 0.024664f
Cext_8019 VSS.$388.met2 net1.$612.met2 0.106947f
Cext_8020 VSS.$388.met2 net1.P100.li1 0.0149836f
Cext_8021 VSS.$388.met2 sky130_gnd 0.128003f
Cext_8022 VSS.$389.met2 sky130_gnd 0.116032f
Cext_8023 VSS.$390.met2 sky130_gnd 0.10585f
Cext_8024 VSS.$391.met2 net1.$579.met1 0.00945921f
Cext_8025 VSS.$391.met2 net1.$607.met2 0.00591033f
Cext_8026 VSS.$391.met2 net1.P348.li1 0.00839068f
Cext_8027 VSS.$391.met2 net1.P522.li1 0.00138964f
Cext_8028 VSS.$391.met2 sky130_gnd 0.125435f
Cext_8029 VSS.$392.met2 sky130_gnd 0.0576228f
Cext_8030 VSS.$393.met2 sky130_gnd 0.0313176f
Cext_8031 VSS.$394.met2 net1.$483.met1 0.0301319f
Cext_8032 VSS.$394.met2 net1.$501.met1 0.00116249f
Cext_8033 VSS.$394.met2 net1.$519.met1 0.044288f
Cext_8034 VSS.$394.met2 net1.$555.met1 0.0785359f
Cext_8035 VSS.$394.met2 net1.$573.met1 0.00334284f
Cext_8036 VSS.$394.met2 net1.$607.met2 0.00136967f
Cext_8037 VSS.$394.met2 net1.$608.met2 0.0195821f
Cext_8038 VSS.$394.met2 net1.P522.li1 0.0282468f
Cext_8039 VSS.$394.met2 sky130_gnd 0.112131f
Cext_8040 VSS.$395.met2 sky130_gnd 0.048006f
Cext_8041 VSS.$396.met2 sky130_gnd 0.191364f
Cext_8042 VSS.$397.met2 sky130_gnd 0.0148014f
Cext_8043 VSS.$398.met2 net2.$87.met2 0.0134163f
Cext_8044 VSS.$398.met2 net2.P0.li1 0.00132154f
Cext_8045 VSS.$398.met2 sky130_gnd 0.00645948f
Cext_8046 VSS.$4.li1 net1.$310.met1 0.00644617f
Cext_8047 VSS.$4.li1 net1.$328.met1 0.00657773f
Cext_8048 VSS.$4.li1 net1.$346.met1 0.00657773f
Cext_8049 VSS.$4.li1 net1.$364.met1 0.00657773f
Cext_8050 VSS.$4.li1 net1.$382.met1 0.00520634f
Cext_8051 VSS.$4.li1 net1.$400.met1 0.0154665f
Cext_8052 VSS.$4.li1 net1.P261.li1 0.119758f
Cext_8053 VSS.$4.li1 sky130_gnd 0.510012f
Cext_8054 VSS.$40.li1 sky130_gnd 0.0203285f
Cext_8055 VSS.$400.met2 sky130_gnd 0.0391936f
Cext_8056 VSS.$401.met2 sky130_gnd 0.015035f
Cext_8057 VSS.$402.met2 sky130_gnd 0.0156351f
Cext_8058 VSS.$403.met2 sky130_gnd 0.0599392f
Cext_8059 VSS.$404.met2 sky130_gnd 0.0245792f
Cext_8060 VSS.$405.met2 sky130_gnd 0.0416865f
Cext_8061 VSS.$406.met2 sky130_gnd 0.0360085f
Cext_8062 VSS.$407.met2 sky130_gnd 0.0668116f
Cext_8063 VSS.$408.met2 sky130_gnd 0.0826586f
Cext_8064 VSS.$409.met2 sky130_gnd 0.0837278f
Cext_8065 VSS.$410.met2 sky130_gnd 0.670741f
Cext_8066 VSS.$411.met2 sky130_gnd 0.641401f
Cext_8067 VSS.$412.met3 net1 0.0390921f
Cext_8068 VSS.$412.met3 net1.$298.met1 0.00325908f
Cext_8069 VSS.$412.met3 net1.$316.met1 0.00512826f
Cext_8070 VSS.$412.met3 net1.$322.met1 0.00133513f
Cext_8071 VSS.$412.met3 net1.$600.met2 0.0435714f
Cext_8072 VSS.$412.met3 net1.$616.met3 0.00705609f
Cext_8073 VSS.$412.met3 net1.P0.li1 0.00588416f
Cext_8074 VSS.$412.met3 net1.P435.li1 0.00215961f
Cext_8075 VSS.$412.met3 sky130_gnd 0.0453729f
Cext_8076 VSS.$413.met3 net1 0.00734332f
Cext_8077 VSS.$413.met3 net1.$316.met1 0.00882452f
Cext_8078 VSS.$413.met3 net1.$322.met1 0.0022925f
Cext_8079 VSS.$413.met3 net1.$334.met1 0.01448f
Cext_8080 VSS.$413.met3 net1.$340.met1 0.00373677f
Cext_8081 VSS.$413.met3 net1.$352.met1 0.0140821f
Cext_8082 VSS.$413.met3 net1.$358.met1 0.00357355f
Cext_8083 VSS.$413.met3 net1.$370.met1 0.0111747f
Cext_8084 VSS.$413.met3 net1.$376.met1 0.0029057f
Cext_8085 VSS.$413.met3 net1.$600.met2 0.00813725f
Cext_8086 VSS.$413.met3 net1.$616.met3 0.0164247f
Cext_8087 VSS.$413.met3 net1.P0.li1 0.00503419f
Cext_8088 VSS.$413.met3 net1.P435.li1 0.00217416f
Cext_8089 VSS.$413.met3 sky130_gnd 0.0296029f
Cext_8090 VSS.$414.met3 net1.$364.met1 0.00141533f
Cext_8091 VSS.$414.met3 net1.$382.met1 0.00335811f
Cext_8092 VSS.$414.met3 net1.$400.met1 0.0164593f
Cext_8093 VSS.$414.met3 net1.P261.li1 0.00838581f
Cext_8094 VSS.$414.met3 sky130_gnd 0.132907f
Cext_8095 VSS.$415.met3 sky130_gnd 0.154897f
Cext_8096 VSS.$416.met3 net1.$414.met1 0.0144233f
Cext_8097 VSS.$416.met3 net1.$426.met1 0.0141587f
Cext_8098 VSS.$416.met3 net1.$438.met1 0.00342022f
Cext_8099 VSS.$416.met3 net1.$450.met1 0.0146188f
Cext_8100 VSS.$416.met3 net1.$462.met1 0.0152299f
Cext_8101 VSS.$416.met3 net1.$474.met1 0.0164593f
Cext_8102 VSS.$416.met3 net1.$605.met2 0.00178566f
Cext_8103 VSS.$416.met3 net1.P174.li1 0.0186477f
Cext_8104 VSS.$416.met3 sky130_gnd 0.337044f
Cext_8105 VSS.$417.met3 sky130_gnd 0.0534434f
Cext_8106 VSS.$418.met3 net1.$462.met1 0.0016933f
Cext_8107 VSS.$418.met3 net1.$482.met1 0.00252693f
Cext_8108 VSS.$418.met3 net1.$606.met2 0.0139679f
Cext_8109 VSS.$418.met3 net1.$612.met2 0.0330636f
Cext_8110 VSS.$418.met3 net1.$619.met3 0.00268116f
Cext_8111 VSS.$418.met3 net1.P100.li1 0.00827428f
Cext_8112 VSS.$418.met3 net1.P348.li1 0.00112076f
Cext_8113 VSS.$418.met3 sky130_gnd 0.0260377f
Cext_8114 VSS.$419.met3 net1.$612.met2 0.00632553f
Cext_8115 VSS.$419.met3 net1.P174.li1 0.00240386f
Cext_8116 VSS.$419.met3 sky130_gnd 0.252736f
Cext_8117 VSS.$42.li1 sky130_gnd 0.0203285f
Cext_8118 VSS.$420.met3 net1.$495.met1 0.00644532f
Cext_8119 VSS.$420.met3 net1.$507.met1 0.00203388f
Cext_8120 VSS.$420.met3 net1.$513.met1 0.0289904f
Cext_8121 VSS.$420.met3 net1.$531.met1 0.0196745f
Cext_8122 VSS.$420.met3 net1.$567.met1 0.0141105f
Cext_8123 VSS.$420.met3 net1.$606.met2 0.0139679f
Cext_8124 VSS.$420.met3 net1.$612.met2 0.0333034f
Cext_8125 VSS.$420.met3 net1.P100.li1 0.00697339f
Cext_8126 VSS.$420.met3 sky130_gnd 0.0275512f
Cext_8127 VSS.$421.met3 sky130_gnd 0.230666f
Cext_8128 VSS.$422.met3 sky130_gnd 0.0106571f
Cext_8129 VSS.$423.met3 net2 0.0142246f
Cext_8130 VSS.$423.met3 net2.$44.met1 0.00405217f
Cext_8131 VSS.$423.met3 net2.$50.met1 0.0176431f
Cext_8132 VSS.$423.met3 net2.$56.met1 0.01896f
Cext_8133 VSS.$423.met3 net2.$62.met1 0.0176431f
Cext_8134 VSS.$423.met3 net2.$68.met1 0.00684577f
Cext_8135 VSS.$423.met3 net2.P0.li1 0.0135396f
Cext_8136 VSS.$423.met3 sky130_gnd 0.269307f
Cext_8137 VSS.$424.met3 sky130_gnd 0.0866506f
Cext_8138 VSS.$425.met3 net2.$68.met1 0.011528f
Cext_8139 VSS.$425.met3 net2.$74.met1 0.0198633f
Cext_8140 VSS.$425.met3 net2.P0.li1 0.0100826f
Cext_8141 VSS.$425.met3 sky130_gnd 0.116187f
Cext_8142 VSS.$426.met3 sky130_gnd 0.0213521f
Cext_8143 VSS.$427.met3 sky130_gnd 0.0661346f
Cext_8144 VSS.$428.met3 sky130_gnd 0.3769f
Cext_8145 VSS.$429.met3 sky130_gnd 0.357067f
Cext_8146 VSS.$44.li1 sky130_gnd 0.0119862f
Cext_8147 VSS.$46.li1 sky130_gnd 0.0103803f
Cext_8148 VSS.$477.poly sky130_gnd 0.0516217f
Cext_8149 VSS.$479.poly sky130_gnd 0.0297054f
Cext_8150 VSS.$48.li1 sky130_gnd 0.0103803f
Cext_8151 VSS.$481.poly sky130_gnd 0.0297054f
Cext_8152 VSS.$483.poly sky130_gnd 0.0297054f
Cext_8153 VSS.$485.poly sky130_gnd 0.0297054f
Cext_8154 VSS.$487.poly sky130_gnd 0.0297054f
Cext_8155 VSS.$489.poly sky130_gnd 0.0297054f
Cext_8156 VSS.$491.poly sky130_gnd 0.0297054f
Cext_8157 VSS.$493.poly sky130_gnd 0.0297054f
Cext_8158 VSS.$495.poly sky130_gnd 0.0297054f
Cext_8159 VSS.$497.poly sky130_gnd 0.0297054f
Cext_8160 VSS.$499.poly sky130_gnd 0.0297054f
Cext_8161 VSS.$5.li1 net1.$322.met1 0.00345455f
Cext_8162 VSS.$5.li1 net1.$340.met1 0.00657773f
Cext_8163 VSS.$5.li1 net1.$358.met1 0.00657773f
Cext_8164 VSS.$5.li1 net1.$376.met1 0.00642535f
Cext_8165 VSS.$5.li1 net1.$394.met1 0.0264664f
Cext_8166 VSS.$5.li1 net1.$600.met2 0.0291379f
Cext_8167 VSS.$5.li1 net1.$616.met3 0.00210326f
Cext_8168 VSS.$5.li1 net1.$617.met3 0.00176478f
Cext_8169 VSS.$5.li1 net1.$618.met3 0.00182982f
Cext_8170 VSS.$5.li1 net1.P435.li1 0.104992f
Cext_8171 VSS.$5.li1 sky130_gnd 0.35145f
Cext_8172 VSS.$50.li1 sky130_gnd 0.0103803f
Cext_8173 VSS.$501.poly sky130_gnd 0.0297054f
Cext_8174 VSS.$503.poly sky130_gnd 0.0297054f
Cext_8175 VSS.$505.poly sky130_gnd 0.0297054f
Cext_8176 VSS.$507.poly sky130_gnd 0.0297054f
Cext_8177 VSS.$509.poly sky130_gnd 0.0297054f
Cext_8178 VSS.$511.poly sky130_gnd 0.0297054f
Cext_8179 VSS.$513.poly sky130_gnd 0.0297054f
Cext_8180 VSS.$515.poly sky130_gnd 0.0297054f
Cext_8181 VSS.$517.poly sky130_gnd 0.0297054f
Cext_8182 VSS.$519.poly sky130_gnd 0.0478623f
Cext_8183 VSS.$52.li1 sky130_gnd 0.0103803f
Cext_8184 VSS.$54.li1 sky130_gnd 0.0103803f
Cext_8185 VSS.$56.li1 sky130_gnd 0.0164023f
Cext_8186 VSS.$58.li1 net1.$474.met1 0.0023414f
Cext_8187 VSS.$58.li1 net1.$495.met1 0.0172833f
Cext_8188 VSS.$58.li1 net1.$513.met1 0.00657773f
Cext_8189 VSS.$58.li1 net1.$531.met1 0.00520434f
Cext_8190 VSS.$58.li1 net1.$549.met1 0.00190471f
Cext_8191 VSS.$58.li1 net1.$612.met2 0.033476f
Cext_8192 VSS.$58.li1 net1.$613.met2 0.00869625f
Cext_8193 VSS.$58.li1 net1.P100.li1 0.0674796f
Cext_8194 VSS.$58.li1 sky130_gnd 0.558852f
Cext_8195 VSS.$59.li1 net1.$474.met1 0.00734566f
Cext_8196 VSS.$59.li1 net1.$482.met1 0.00738981f
Cext_8197 VSS.$59.li1 net1.$495.met1 0.0264094f
Cext_8198 VSS.$59.li1 net1.$513.met1 0.00657773f
Cext_8199 VSS.$59.li1 net1.$531.met1 0.00456269f
Cext_8200 VSS.$59.li1 net1.$606.met2 0.00753523f
Cext_8201 VSS.$59.li1 net1.$612.met2 0.079229f
Cext_8202 VSS.$59.li1 net1.$619.met3 0.00899517f
Cext_8203 VSS.$59.li1 net1.P100.li1 0.110114f
Cext_8204 VSS.$59.li1 sky130_gnd 0.648776f
Cext_8205 VSS.$6.li1 sky130_gnd 0.491603f
Cext_8206 VSS.$60.li1 net1.$468.met1 0.00149186f
Cext_8207 VSS.$60.li1 net1.$480.met1 0.00740911f
Cext_8208 VSS.$60.li1 net1.$483.met1 0.0146306f
Cext_8209 VSS.$60.li1 net1.$501.met1 0.00657773f
Cext_8210 VSS.$60.li1 net1.$519.met1 0.00657773f
Cext_8211 VSS.$60.li1 net1.$537.met1 0.00657773f
Cext_8212 VSS.$60.li1 net1.$555.met1 0.00657773f
Cext_8213 VSS.$60.li1 net1.$573.met1 0.00356793f
Cext_8214 VSS.$60.li1 net1.$608.met2 0.0227646f
Cext_8215 VSS.$60.li1 net1.$609.met2 0.0382742f
Cext_8216 VSS.$60.li1 net1.$620.met3 0.0449569f
Cext_8217 VSS.$60.li1 net1.P522.li1 0.111428f
Cext_8218 VSS.$60.li1 sky130_gnd 0.609378f
Cext_8219 VSS.$61.li1 net1.$481.met1 0.00738981f
Cext_8220 VSS.$61.li1 net1.$483.met1 0.00217814f
Cext_8221 VSS.$61.li1 net1.$489.met1 0.0146752f
Cext_8222 VSS.$61.li1 net1.$501.met1 0.00241742f
Cext_8223 VSS.$61.li1 net1.$507.met1 0.00692071f
Cext_8224 VSS.$61.li1 net1.$519.met1 0.00202608f
Cext_8225 VSS.$61.li1 net1.$525.met1 0.00685308f
Cext_8226 VSS.$61.li1 net1.$543.met1 0.00657773f
Cext_8227 VSS.$61.li1 net1.$561.met1 0.00338216f
Cext_8228 VSS.$61.li1 net1.$606.met2 0.0205786f
Cext_8229 VSS.$61.li1 net1.$607.met2 0.138267f
Cext_8230 VSS.$61.li1 net1.$608.met2 0.00834276f
Cext_8231 VSS.$61.li1 net1.$611.met2 0.00464594f
Cext_8232 VSS.$61.li1 net1.$619.met3 0.0317591f
Cext_8233 VSS.$61.li1 net1.$620.met3 0.00558272f
Cext_8234 VSS.$61.li1 net1.P348.li1 0.108704f
Cext_8235 VSS.$61.li1 sky130_gnd 0.648866f
Cext_8236 VSS.$62.li1 sky130_gnd 0.181925f
Cext_8237 VSS.$63.li1 net1.$573.met1 0.0470583f
Cext_8238 VSS.$63.li1 net1.$620.met3 0.00191372f
Cext_8239 VSS.$63.li1 net1.P522.li1 0.120365f
Cext_8240 VSS.$63.li1 sky130_gnd 0.510232f
Cext_8241 VSS.$64.li1 net1.$561.met1 0.00319557f
Cext_8242 VSS.$64.li1 net1.$579.met1 0.0296362f
Cext_8243 VSS.$64.li1 net1.$619.met3 0.00123129f
Cext_8244 VSS.$64.li1 net1.P348.li1 0.0670878f
Cext_8245 VSS.$64.li1 net2 0.00165586f
Cext_8246 VSS.$64.li1 sky130_gnd 0.423935f
Cext_8247 VSS.$65.li1 sky130_gnd 0.0329189f
Cext_8248 VSS.$67.li1 sky130_gnd 0.0203285f
Cext_8249 VSS.$69.li1 sky130_gnd 0.0203285f
Cext_8250 VSS.$7.li1 net1.$408.met1 0.00186662f
Cext_8251 VSS.$7.li1 net1.$420.met1 0.00190471f
Cext_8252 VSS.$7.li1 net1.$432.met1 0.00190471f
Cext_8253 VSS.$7.li1 net1.$444.met1 0.00190471f
Cext_8254 VSS.$7.li1 net1.$607.met2 0.00466494f
Cext_8255 VSS.$7.li1 net1.$617.met3 0.00559671f
Cext_8256 VSS.$7.li1 net1.$618.met3 0.00356464f
Cext_8257 VSS.$7.li1 sky130_gnd 0.267415f
Cext_8258 VSS.$71.li1 sky130_gnd 0.0203285f
Cext_8259 VSS.$73.li1 sky130_gnd 0.0108138f
Cext_8260 VSS.$75.li1 sky130_gnd 0.0103803f
Cext_8261 VSS.$77.li1 sky130_gnd 0.0103803f
Cext_8262 VSS.$79.li1 sky130_gnd 0.0103803f
Cext_8263 VSS.$8.li1 net1.$604.met2 0.0436987f
Cext_8264 VSS.$8.li1 net1.$605.met2 0.00874456f
Cext_8265 VSS.$8.li1 net1.$618.met3 0.00581428f
Cext_8266 VSS.$8.li1 sky130_gnd 0.37974f
Cext_8267 VSS.$81.li1 sky130_gnd 0.0103803f
Cext_8268 VSS.$83.li1 sky130_gnd 0.0103803f
Cext_8269 VSS.$85.li1 sky130_gnd 0.00995459f
Cext_8270 VSS.$87.li1 sky130_gnd 0.00995459f
Cext_8271 VSS.$89.li1 sky130_gnd 0.0103803f
Cext_8272 VSS.$9.li1 net1.$414.met1 0.0170088f
Cext_8273 VSS.$9.li1 net1.$426.met1 0.00657773f
Cext_8274 VSS.$9.li1 net1.$438.met1 0.00520434f
Cext_8275 VSS.$9.li1 net1.$450.met1 0.00190471f
Cext_8276 VSS.$9.li1 net1.P174.li1 0.0683647f
Cext_8277 VSS.$9.li1 sky130_gnd 0.448021f
Cext_8278 VSS.$91.li1 sky130_gnd 0.0103803f
Cext_8279 VSS.$93.li1 sky130_gnd 0.0103803f
Cext_8280 VSS.$95.li1 sky130_gnd 0.0103803f
Cext_8281 VSS.$97.li1 sky130_gnd 0.0103803f
Cext_8282 VSS.P0.li1 net1 0.00807046f
Cext_8283 VSS.P0.li1 net1.$295.met1 0.00914231f
Cext_8284 VSS.P0.li1 net1.$298.met1 0.00537333f
Cext_8285 VSS.P0.li1 net1.$316.met1 0.00657773f
Cext_8286 VSS.P0.li1 net1.$334.met1 0.00657773f
Cext_8287 VSS.P0.li1 net1.$352.met1 0.00657773f
Cext_8288 VSS.P0.li1 net1.$370.met1 0.00657773f
Cext_8289 VSS.P0.li1 net1.$388.met1 0.0384223f
Cext_8290 VSS.P0.li1 net1.$408.met1 0.00169513f
Cext_8291 VSS.P0.li1 net1.$598.met2 0.00859252f
Cext_8292 VSS.P0.li1 net1.$616.met3 0.0692854f
Cext_8293 VSS.P0.li1 net1.$617.met3 0.0196518f
Cext_8294 VSS.P0.li1 net1.P0.li1 0.215743f
Cext_8295 VSS.P0.li1 sky130_gnd 0.640941f
Cext_8296 VSS.P10.li1 net1.$296.met1 0.00906263f
Cext_8297 VSS.P10.li1 net1.$304.met1 0.0359281f
Cext_8298 VSS.P10.li1 net1.$322.met1 0.00312318f
Cext_8299 VSS.P10.li1 net1.$394.met1 0.0121912f
Cext_8300 VSS.P10.li1 net1.$600.met2 0.0747977f
Cext_8301 VSS.P10.li1 net1.P435.li1 0.17331f
Cext_8302 VSS.P10.li1 sky130_gnd 0.326461f
Cext_8303 VSS.P12.li1 net1.$468.met1 0.00151774f
Cext_8304 VSS.P12.li1 net1.$483.met1 0.0262113f
Cext_8305 VSS.P12.li1 net1.$501.met1 0.00467302f
Cext_8306 VSS.P12.li1 net1.$519.met1 0.00506436f
Cext_8307 VSS.P12.li1 net1.$537.met1 0.00657773f
Cext_8308 VSS.P12.li1 net1.$555.met1 0.00584532f
Cext_8309 VSS.P12.li1 net1.$573.met1 0.00379913f
Cext_8310 VSS.P12.li1 net1.$608.met2 0.0746034f
Cext_8311 VSS.P12.li1 net1.$609.met2 0.00468506f
Cext_8312 VSS.P12.li1 net1.$619.met3 0.00433531f
Cext_8313 VSS.P12.li1 net1.$620.met3 0.0245308f
Cext_8314 VSS.P12.li1 net1.P522.li1 0.166091f
Cext_8315 VSS.P12.li1 sky130_gnd 0.134443f
Cext_8316 VSS.P14.li1 net1.$406.met1 0.00904688f
Cext_8317 VSS.P14.li1 net1.$408.met1 0.00537333f
Cext_8318 VSS.P14.li1 net1.$420.met1 0.00657773f
Cext_8319 VSS.P14.li1 net1.$432.met1 0.0078334f
Cext_8320 VSS.P14.li1 net1.$444.met1 0.0112507f
Cext_8321 VSS.P14.li1 net1.$456.met1 0.0131555f
Cext_8322 VSS.P14.li1 net1.$468.met1 0.0548583f
Cext_8323 VSS.P14.li1 net1.$483.met1 0.00269172f
Cext_8324 VSS.P14.li1 net1.$602.met2 0.00852072f
Cext_8325 VSS.P14.li1 net1.$607.met2 0.00163789f
Cext_8326 VSS.P14.li1 net1.$608.met2 0.0154526f
Cext_8327 VSS.P14.li1 net1.$609.met2 0.00299061f
Cext_8328 VSS.P14.li1 net1.$617.met3 0.105046f
Cext_8329 VSS.P14.li1 net1.$618.met3 0.00510406f
Cext_8330 VSS.P14.li1 net1.$619.met3 0.00642691f
Cext_8331 VSS.P14.li1 net1.$620.met3 0.0304547f
Cext_8332 VSS.P14.li1 net1.P609.li1 0.292437f
Cext_8333 VSS.P14.li1 sky130_gnd 0.789569f
Cext_8334 VSS.P16.li1 net2 0.12006f
Cext_8335 VSS.P16.li1 net2.$44.met1 0.0292882f
Cext_8336 VSS.P16.li1 net2.$50.met1 0.00657773f
Cext_8337 VSS.P16.li1 net2.$56.met1 0.00657773f
Cext_8338 VSS.P16.li1 net2.$62.met1 0.00657773f
Cext_8339 VSS.P16.li1 net2.$68.met1 0.00657773f
Cext_8340 VSS.P16.li1 net2.$74.met1 0.0263921f
Cext_8341 VSS.P16.li1 net2.P0.li1 0.218049f
Cext_8342 VSS.P16.li1 sky130_gnd 0.730761f
Cext_8343 VSS.P18.li1 net1.$489.met1 0.00262507f
Cext_8344 VSS.P18.li1 net1.$606.met2 0.0129193f
Cext_8345 VSS.P18.li1 net1.$607.met2 0.0132701f
Cext_8346 VSS.P18.li1 net1.$617.met3 0.00417624f
Cext_8347 VSS.P18.li1 net1.$618.met3 0.0346f
Cext_8348 VSS.P18.li1 net1.$619.met3 0.06123f
Cext_8349 VSS.P18.li1 sky130_gnd 0.470385f
Cext_8350 VSS.P2.li1 net1.$531.met1 0.00338842f
Cext_8351 VSS.P2.li1 net1.$549.met1 0.0103917f
Cext_8352 VSS.P2.li1 net1.$567.met1 0.0121893f
Cext_8353 VSS.P2.li1 net1.$585.met1 0.0548583f
Cext_8354 VSS.P2.li1 net1.$612.met2 0.0437414f
Cext_8355 VSS.P2.li1 net1.P100.li1 0.21955f
Cext_8356 VSS.P2.li1 net2 0.00746598f
Cext_8357 VSS.P2.li1 net2.$88.met2 0.00315061f
Cext_8358 VSS.P2.li1 sky130_gnd 0.701391f
Cext_8359 VSS.P4.li1 net1.$438.met1 0.00338842f
Cext_8360 VSS.P4.li1 net1.$450.met1 0.0103917f
Cext_8361 VSS.P4.li1 net1.$462.met1 0.0121893f
Cext_8362 VSS.P4.li1 net1.$474.met1 0.0480098f
Cext_8363 VSS.P4.li1 net1.$495.met1 0.00175425f
Cext_8364 VSS.P4.li1 net1.$612.met2 0.0048627f
Cext_8365 VSS.P4.li1 net1.$618.met3 0.00461301f
Cext_8366 VSS.P4.li1 net1.$619.met3 0.00113884f
Cext_8367 VSS.P4.li1 net1.P174.li1 0.218904f
Cext_8368 VSS.P4.li1 sky130_gnd 0.217741f
Cext_8369 VSS.P6.li1 net1.$310.met1 0.00379913f
Cext_8370 VSS.P6.li1 net1.$346.met1 0.00201504f
Cext_8371 VSS.P6.li1 net1.$364.met1 0.00467302f
Cext_8372 VSS.P6.li1 net1.$382.met1 0.00467302f
Cext_8373 VSS.P6.li1 net1.$400.met1 0.031927f
Cext_8374 VSS.P6.li1 net1.$414.met1 0.00134055f
Cext_8375 VSS.P6.li1 net1.P261.li1 0.165787f
Cext_8376 VSS.P6.li1 sky130_gnd 0.0403621f
Cext_8377 VSS.P8.li1 net1.$489.met1 0.0281247f
Cext_8378 VSS.P8.li1 net1.$507.met1 0.00657773f
Cext_8379 VSS.P8.li1 net1.$525.met1 0.00657773f
Cext_8380 VSS.P8.li1 net1.$543.met1 0.00657773f
Cext_8381 VSS.P8.li1 net1.$561.met1 0.00657773f
Cext_8382 VSS.P8.li1 net1.$579.met1 0.0263921f
Cext_8383 VSS.P8.li1 net1.$606.met2 0.0783039f
Cext_8384 VSS.P8.li1 net1.$607.met2 0.00548453f
Cext_8385 VSS.P8.li1 net1.$612.met2 0.00845447f
Cext_8386 VSS.P8.li1 net1.$619.met3 0.0269294f
Cext_8387 VSS.P8.li1 net1.P348.li1 0.22166f
Cext_8388 VSS.P8.li1 net2 0.00403768f
Cext_8389 VSS.P8.li1 sky130_gnd 0.506255f
Cext_8390 sky130_gnd net1 0.0787599f
Cext_8391 sky130_gnd net1.$288.li1 0.0146524f
Cext_8392 sky130_gnd net1.$289.li1 0.0392913f
Cext_8393 sky130_gnd net1.$290.li1 0.0293049f
Cext_8394 sky130_gnd net1.$291.li1 0.0221821f
Cext_8395 sky130_gnd net1.$292.li1 0.0217751f
Cext_8396 sky130_gnd net1.$293.li1 0.0293049f
Cext_8397 sky130_gnd net1.$294.li1 0.0439569f
Cext_8398 sky130_gnd net1.$295.met1 0.016294f
Cext_8399 sky130_gnd net1.$296.met1 0.0126855f
Cext_8400 sky130_gnd net1.$297.met1 0.00597328f
Cext_8401 sky130_gnd net1.$298.met1 0.0604625f
Cext_8402 sky130_gnd net1.$304.met1 0.0609268f
Cext_8403 sky130_gnd net1.$310.met1 0.0652763f
Cext_8404 sky130_gnd net1.$316.met1 0.016018f
Cext_8405 sky130_gnd net1.$322.met1 0.0116842f
Cext_8406 sky130_gnd net1.$328.met1 0.016018f
Cext_8407 sky130_gnd net1.$334.met1 0.016018f
Cext_8408 sky130_gnd net1.$340.met1 0.0116842f
Cext_8409 sky130_gnd net1.$346.met1 0.016018f
Cext_8410 sky130_gnd net1.$352.met1 0.0158821f
Cext_8411 sky130_gnd net1.$358.met1 0.011517f
Cext_8412 sky130_gnd net1.$364.met1 0.01588f
Cext_8413 sky130_gnd net1.$370.met1 0.0123052f
Cext_8414 sky130_gnd net1.$376.met1 0.00766005f
Cext_8415 sky130_gnd net1.$382.met1 0.00927199f
Cext_8416 sky130_gnd net1.$388.met1 0.053046f
Cext_8417 sky130_gnd net1.$394.met1 0.0475076f
Cext_8418 sky130_gnd net1.$400.met1 0.0533594f
Cext_8419 sky130_gnd net1.$406.met1 0.0126609f
Cext_8420 sky130_gnd net1.$407.met1 0.00526484f
Cext_8421 sky130_gnd net1.$408.met1 0.0378499f
Cext_8422 sky130_gnd net1.$414.met1 0.0421477f
Cext_8423 sky130_gnd net1.$420.met1 0.0159134f
Cext_8424 sky130_gnd net1.$426.met1 0.0158314f
Cext_8425 sky130_gnd net1.$432.met1 0.0159134f
Cext_8426 sky130_gnd net1.$438.met1 0.0158314f
Cext_8427 sky130_gnd net1.$444.met1 0.016018f
Cext_8428 sky130_gnd net1.$450.met1 0.016018f
Cext_8429 sky130_gnd net1.$456.met1 0.016018f
Cext_8430 sky130_gnd net1.$462.met1 0.016018f
Cext_8431 sky130_gnd net1.$468.met1 0.053387f
Cext_8432 sky130_gnd net1.$474.met1 0.0532324f
Cext_8433 sky130_gnd net1.$480.met1 0.00591732f
Cext_8434 sky130_gnd net1.$481.met1 0.00526484f
Cext_8435 sky130_gnd net1.$482.met1 0.00523348f
Cext_8436 sky130_gnd net1.$483.met1 0.0385261f
Cext_8437 sky130_gnd net1.$489.met1 0.0375577f
Cext_8438 sky130_gnd net1.$495.met1 0.0420745f
Cext_8439 sky130_gnd net1.$501.met1 0.016018f
Cext_8440 sky130_gnd net1.$507.met1 0.0115797f
Cext_8441 sky130_gnd net1.$513.met1 0.0159134f
Cext_8442 sky130_gnd net1.$519.met1 0.016018f
Cext_8443 sky130_gnd net1.$525.met1 0.0115797f
Cext_8444 sky130_gnd net1.$531.met1 0.0159134f
Cext_8445 sky130_gnd net1.$537.met1 0.016018f
Cext_8446 sky130_gnd net1.$543.met1 0.0116842f
Cext_8447 sky130_gnd net1.$549.met1 0.016018f
Cext_8448 sky130_gnd net1.$555.met1 0.016018f
Cext_8449 sky130_gnd net1.$561.met1 0.0116842f
Cext_8450 sky130_gnd net1.$567.met1 0.016018f
Cext_8451 sky130_gnd net1.$573.met1 0.0736111f
Cext_8452 sky130_gnd net1.$579.met1 0.064999f
Cext_8453 sky130_gnd net1.$585.met1 0.0800129f
Cext_8454 sky130_gnd net1.$591.met1 0.0320694f
Cext_8455 sky130_gnd net1.$592.met1 0.0252316f
Cext_8456 sky130_gnd net1.$593.met1 0.0148986f
Cext_8457 sky130_gnd net1.$594.met1 0.0207895f
Cext_8458 sky130_gnd net1.$595.met1 0.0286468f
Cext_8459 sky130_gnd net1.$596.met1 0.0286468f
Cext_8460 sky130_gnd net1.$597.met1 0.0366827f
Cext_8461 sky130_gnd net1.$598.met2 0.0195624f
Cext_8462 sky130_gnd net1.$600.met2 0.243806f
Cext_8463 sky130_gnd net1.$601.met2 0.152476f
Cext_8464 sky130_gnd net1.$602.met2 0.0144487f
Cext_8465 sky130_gnd net1.$603.met2 0.00349681f
Cext_8466 sky130_gnd net1.$604.met2 0.00274081f
Cext_8467 sky130_gnd net1.$605.met2 0.0370806f
Cext_8468 sky130_gnd net1.$606.met2 0.0552272f
Cext_8469 sky130_gnd net1.$607.met2 0.152212f
Cext_8470 sky130_gnd net1.$608.met2 0.0535393f
Cext_8471 sky130_gnd net1.$609.met2 0.0358463f
Cext_8472 sky130_gnd net1.$611.met2 0.00276372f
Cext_8473 sky130_gnd net1.$612.met2 0.289145f
Cext_8474 sky130_gnd net1.$613.met2 0.409445f
Cext_8475 sky130_gnd net1.$614.met2 0.114552f
Cext_8476 sky130_gnd net1.$615.met2 0.100679f
Cext_8477 sky130_gnd net1.$616.met3 0.146207f
Cext_8478 sky130_gnd net1.$617.met3 0.365495f
Cext_8479 sky130_gnd net1.$618.met3 0.0669714f
Cext_8480 sky130_gnd net1.$619.met3 0.190135f
Cext_8481 sky130_gnd net1.$620.met3 0.239528f
Cext_8482 sky130_gnd net1.$621.met3 1.58411f
Cext_8483 sky130_gnd net1.$622.met3 1.3191f
Cext_8484 sky130_gnd net1.$623.poly 0.169993f
Cext_8485 sky130_gnd net1.P0.poly 0.176631f
Cext_8486 sky130_gnd net2 0.631468f
Cext_8487 sky130_gnd net2.$36.li1 0.0146524f
Cext_8488 sky130_gnd net2.$37.li1 0.0439201f
Cext_8489 sky130_gnd net2.$38.li1 0.0293049f
Cext_8490 sky130_gnd net2.$39.li1 0.0221821f
Cext_8491 sky130_gnd net2.$40.li1 0.0217751f
Cext_8492 sky130_gnd net2.$41.li1 0.0293049f
Cext_8493 sky130_gnd net2.$42.li1 0.0404495f
Cext_8494 sky130_gnd net2.$43.met1 0.00814622f
Cext_8495 sky130_gnd net2.$44.met1 0.0572966f
Cext_8496 sky130_gnd net2.$50.met1 0.0203517f
Cext_8497 sky130_gnd net2.$56.met1 0.0203517f
Cext_8498 sky130_gnd net2.$62.met1 0.0203517f
Cext_8499 sky130_gnd net2.$68.met1 0.0203517f
Cext_8500 sky130_gnd net2.$74.met1 0.0848667f
Cext_8501 sky130_gnd net2.$80.met1 0.0325051f
Cext_8502 sky130_gnd net2.$81.met1 0.0148627f
Cext_8503 sky130_gnd net2.$82.met1 0.0217394f
Cext_8504 sky130_gnd net2.$83.met1 0.0286468f
Cext_8505 sky130_gnd net2.$84.met1 0.0286468f
Cext_8506 sky130_gnd net2.$85.met1 0.0286468f
Cext_8507 sky130_gnd net2.$86.met1 0.0333666f
Cext_8508 sky130_gnd net2.$87.met2 0.00785587f
Cext_8509 sky130_gnd net2.$88.met2 0.925563f
Cext_8510 sky130_gnd net2.$89.met2 0.155813f
Cext_8511 sky130_gnd net2.$90.met2 0.144966f
Cext_8512 sky130_gnd net2.$91.met3 0.941574f
Cext_8513 sky130_gnd net2.$92.met3 1.25908f
Cext_8514 sky130_gnd net2.$93.poly 0.1722f
Cext_8515 sky130_gnd net2.P0.poly 0.174903f
Rext_1 A A.$174.met2 0.0143957131568
Rext_2 A A.$175.met2 8.50033735398
Rext_3 A.$100.met1 A.$101.met1 0.0204918032787
Rext_4 A.$100.met1 A.$89.met1 0.0205252370824
Rext_5 A.$100.met1 A.P0.li1 1.55
Rext_6 A.$101.met1 A.$107.met1 0.0204918032787
Rext_7 A.$101.met1 A.P0.li1 1.55
Rext_8 A.$107.met1 A.$113.met1 0.0204918032787
Rext_9 A.$107.met1 A.P0.li1 1.55
Rext_10 A.$113.met1 A.$119.met1 0.0204918032787
Rext_11 A.$113.met1 A.P0.li1 1.55
Rext_12 A.$119.met1 A.P0.li1 1.55
Rext_13 A.$125.met1 A.$126.met1 0.021377672209
Rext_14 A.$125.met1 A.$141.met1 0.000890736342043
Rext_15 A.$125.met1 A.$40.li1 1.55
Rext_16 A.$126.met1 A.$127.met1 0.021377672209
Rext_17 A.$126.met1 A.$41.li1 1.55
Rext_18 A.$127.met1 A.$128.met1 0.021377672209
Rext_19 A.$127.met1 A.$42.li1 1.55
Rext_20 A.$128.met1 A.$129.met1 0.021377672209
Rext_21 A.$128.met1 A.$43.li1 1.55
Rext_22 A.$129.met1 A.$130.met1 0.021377672209
Rext_23 A.$129.met1 A.$44.li1 1.55
Rext_24 A.$130.met1 A.$131.met1 0.021377672209
Rext_25 A.$130.met1 A.$45.li1 1.55
Rext_26 A.$131.met1 A.$132.met1 0.021377672209
Rext_27 A.$131.met1 A.$46.li1 1.55
Rext_28 A.$132.met1 A.$47.li1 1.55
Rext_29 A.$141.met1 A.$177.met2 4.5
Rext_30 A.$174.met2 A.$88.met1 4.5
Rext_31 A.$175.met2 A.$178.met3 3.41
Rext_32 A.$176.met2 A.$177.met2 1.28318348027
Rext_33 A.$176.met2 A.$179.met3 3.41
Rext_34 A.$178.met3 A.$179.met3 5.499
Rext_35 A.$180.poly A.$181.poly 16.2961904762
Rext_36 A.$180.poly A.$36.li1 11.56
Rext_37 A.$181.poly A.$37.li1 11.56
Rext_38 A.$181.poly A.P0.poly 8.1480952381
Rext_39 A.$182.poly A.$183.poly 16.2961904762
Rext_40 A.$182.poly A.$38.li1 11.56
Rext_41 A.$182.poly A.P0.poly 8.1480952381
Rext_42 A.$183.poly A.$39.li1 11.56
Rext_43 A.$36.li1 A.$40.li1 1.15555555556
Rext_44 A.$36.li1 A.$41.li1 0.977777777778
Rext_45 A.$37.li1 A.$42.li1 1.0962962963
Rext_46 A.$37.li1 A.$43.li1 1.03703703704
Rext_47 A.$38.li1 A.$44.li1 1.03703703704
Rext_48 A.$38.li1 A.$45.li1 1.0962962963
Rext_49 A.$39.li1 A.$46.li1 0.977777777778
Rext_50 A.$39.li1 A.$47.li1 1.15555555556
Rext_51 A.$41.li1 A.$42.li1 2.13333333333
Rext_52 A.$43.li1 A.$44.li1 2.13333333333
Rext_53 A.$45.li1 A.$46.li1 2.13333333333
Rext_54 A.$88.met1 A.$89.met1 0.00734889408025
Rext_55 A.$89.met1 A.P0.li1 1.55
Rext_56 AH AH.$236.met2 0.0835848220124
Rext_57 AH AH.$237.met2 7.50060752679
Rext_58 AH.$0.li1 AH.$12.li1 1.15555555556
Rext_59 AH.$0.li1 AH.$13.li1 0.977777777778
Rext_60 AH.$0.li1 AH.$239.poly 11.56
Rext_61 AH.$1.li1 AH.$14.li1 1.0962962963
Rext_62 AH.$1.li1 AH.$15.li1 1.03703703704
Rext_63 AH.$1.li1 AH.$240.poly 11.56
Rext_64 AH.$10.li1 AH.$146.met1 1.55
Rext_65 AH.$10.li1 AH.$17.li1 2.13333333333
Rext_66 AH.$10.li1 AH.$3.li1 0.977777777778
Rext_67 AH.$100.li1 AH.$104.li1 27.1058823529
Rext_68 AH.$100.li1 AH.$215.met1 9.3
Rext_69 AH.$100.li1 AH.$243.poly 152
Rext_70 AH.$100.li1 AH.$96.li1 27.1058823529
Rext_71 AH.$102.li1 AH.$106.li1 27.1058823529
Rext_72 AH.$102.li1 AH.$216.met1 9.3
Rext_73 AH.$102.li1 AH.$244.poly 152
Rext_74 AH.$102.li1 AH.$98.li1 27.1058823529
Rext_75 AH.$104.li1 AH.$108.li1 27.1058823529
Rext_76 AH.$104.li1 AH.$217.met1 9.3
Rext_77 AH.$104.li1 AH.$243.poly 152
Rext_78 AH.$106.li1 AH.$110.li1 27.1058823529
Rext_79 AH.$106.li1 AH.$218.met1 9.3
Rext_80 AH.$106.li1 AH.$244.poly 152
Rext_81 AH.$108.li1 AH.$112.li1 27.1058823529
Rext_82 AH.$108.li1 AH.$219.met1 9.3
Rext_83 AH.$108.li1 AH.$243.poly 152
Rext_84 AH.$11.li1 AH.$147.met1 1.55
Rext_85 AH.$11.li1 AH.$3.li1 1.15555555556
Rext_86 AH.$110.li1 AH.$114.li1 27.1058823529
Rext_87 AH.$110.li1 AH.$220.met1 9.3
Rext_88 AH.$110.li1 AH.$244.poly 152
Rext_89 AH.$112.li1 AH.$116.li1 27.1058823529
Rext_90 AH.$112.li1 AH.$221.met1 9.3
Rext_91 AH.$112.li1 AH.$243.poly 152
Rext_92 AH.$114.li1 AH.$118.li1 27.1058823529
Rext_93 AH.$114.li1 AH.$222.met1 9.3
Rext_94 AH.$114.li1 AH.$244.poly 152
Rext_95 AH.$116.li1 AH.$120.li1 27.1058823529
Rext_96 AH.$116.li1 AH.$223.met1 9.3
Rext_97 AH.$116.li1 AH.$243.poly 152
Rext_98 AH.$118.li1 AH.$122.li1 27.1058823529
Rext_99 AH.$118.li1 AH.$224.met1 9.3
Rext_100 AH.$118.li1 AH.$244.poly 152
Rext_101 AH.$12.li1 AH.$140.met1 1.55
Rext_102 AH.$120.li1 AH.$124.li1 27.1058823529
Rext_103 AH.$120.li1 AH.$225.met1 9.3
Rext_104 AH.$120.li1 AH.$243.poly 152
Rext_105 AH.$122.li1 AH.$126.li1 27.1058823529
Rext_106 AH.$122.li1 AH.$226.met1 9.3
Rext_107 AH.$122.li1 AH.$244.poly 152
Rext_108 AH.$124.li1 AH.$128.li1 27.1058823529
Rext_109 AH.$124.li1 AH.$227.met1 9.3
Rext_110 AH.$124.li1 AH.$243.poly 152
Rext_111 AH.$126.li1 AH.$130.li1 27.1058823529
Rext_112 AH.$126.li1 AH.$228.met1 9.3
Rext_113 AH.$126.li1 AH.$244.poly 152
Rext_114 AH.$128.li1 AH.$132.li1 27.1058823529
Rext_115 AH.$128.li1 AH.$229.met1 9.3
Rext_116 AH.$128.li1 AH.$243.poly 152
Rext_117 AH.$13.li1 AH.$14.li1 2.13333333333
Rext_118 AH.$13.li1 AH.$141.met1 1.55
Rext_119 AH.$130.li1 AH.$134.li1 27.1058823529
Rext_120 AH.$130.li1 AH.$230.met1 9.3
Rext_121 AH.$130.li1 AH.$244.poly 152
Rext_122 AH.$132.li1 AH.$136.li1 27.1058823529
Rext_123 AH.$132.li1 AH.$231.met1 9.3
Rext_124 AH.$132.li1 AH.$243.poly 152
Rext_125 AH.$134.li1 AH.$138.li1 27.1058823529
Rext_126 AH.$134.li1 AH.$232.met1 9.3
Rext_127 AH.$134.li1 AH.$244.poly 152
Rext_128 AH.$136.li1 AH.$233.met1 9.3
Rext_129 AH.$136.li1 AH.$243.poly 152
Rext_130 AH.$138.li1 AH.$234.met1 9.3
Rext_131 AH.$138.li1 AH.$244.poly 152
Rext_132 AH.$14.li1 AH.$142.met1 1.55
Rext_133 AH.$140.met1 AH.$141.met1 0.021377672209
Rext_134 AH.$140.met1 AH.$156.met1 0.000890736342043
Rext_135 AH.$141.met1 AH.$142.met1 0.021377672209
Rext_136 AH.$142.met1 AH.$143.met1 0.021377672209
Rext_137 AH.$143.met1 AH.$144.met1 0.021377672209
Rext_138 AH.$143.met1 AH.$15.li1 1.55
Rext_139 AH.$144.met1 AH.$145.met1 0.021377672209
Rext_140 AH.$144.met1 AH.$16.li1 1.55
Rext_141 AH.$145.met1 AH.$146.met1 0.021377672209
Rext_142 AH.$145.met1 AH.$17.li1 1.55
Rext_143 AH.$146.met1 AH.$147.met1 0.021377672209
Rext_144 AH.$15.li1 AH.$16.li1 2.13333333333
Rext_145 AH.$156.met1 AH.$235.met2 4.5
Rext_146 AH.$16.li1 AH.$2.li1 1.03703703704
Rext_147 AH.$17.li1 AH.$2.li1 1.0962962963
Rext_148 AH.$189.met1 AH.$211.met1 0.0298913043478
Rext_149 AH.$189.met1 AH.$52.li1 9.3
Rext_150 AH.$190.met1 AH.$191.met1 0.195652173913
Rext_151 AH.$190.met1 AH.$211.met1 0.165760869565
Rext_152 AH.$190.met1 AH.$54.li1 9.3
Rext_153 AH.$191.met1 AH.$192.met1 0.195652173913
Rext_154 AH.$191.met1 AH.$56.li1 9.3
Rext_155 AH.$192.met1 AH.$193.met1 0.195652173913
Rext_156 AH.$192.met1 AH.$58.li1 9.3
Rext_157 AH.$193.met1 AH.$194.met1 0.195652173913
Rext_158 AH.$193.met1 AH.$60.li1 9.3
Rext_159 AH.$194.met1 AH.$195.met1 0.195652173913
Rext_160 AH.$194.met1 AH.$62.li1 9.3
Rext_161 AH.$195.met1 AH.$196.met1 0.195652173913
Rext_162 AH.$195.met1 AH.$64.li1 9.3
Rext_163 AH.$196.met1 AH.$197.met1 0.195652173913
Rext_164 AH.$196.met1 AH.$66.li1 9.3
Rext_165 AH.$197.met1 AH.$198.met1 0.195652173913
Rext_166 AH.$197.met1 AH.$68.li1 9.3
Rext_167 AH.$198.met1 AH.$199.met1 0.195652173913
Rext_168 AH.$198.met1 AH.$70.li1 9.3
Rext_169 AH.$199.met1 AH.$200.met1 0.195652173913
Rext_170 AH.$199.met1 AH.$72.li1 9.3
Rext_171 AH.$2.li1 AH.$241.poly 11.56
Rext_172 AH.$200.met1 AH.$201.met1 0.195652173913
Rext_173 AH.$200.met1 AH.$74.li1 9.3
Rext_174 AH.$201.met1 AH.$202.met1 0.195652173913
Rext_175 AH.$201.met1 AH.$76.li1 9.3
Rext_176 AH.$202.met1 AH.$203.met1 0.195652173913
Rext_177 AH.$202.met1 AH.$78.li1 9.3
Rext_178 AH.$203.met1 AH.$204.met1 0.195652173913
Rext_179 AH.$203.met1 AH.$80.li1 9.3
Rext_180 AH.$204.met1 AH.$205.met1 0.195652173913
Rext_181 AH.$204.met1 AH.$82.li1 9.3
Rext_182 AH.$205.met1 AH.$206.met1 0.195652173913
Rext_183 AH.$205.met1 AH.$84.li1 9.3
Rext_184 AH.$206.met1 AH.$207.met1 0.195652173913
Rext_185 AH.$206.met1 AH.$86.li1 9.3
Rext_186 AH.$207.met1 AH.$208.met1 0.195652173913
Rext_187 AH.$207.met1 AH.$88.li1 9.3
Rext_188 AH.$208.met1 AH.$209.met1 0.195652173913
Rext_189 AH.$208.met1 AH.$90.li1 9.3
Rext_190 AH.$209.met1 AH.$210.met1 0.195652173913
Rext_191 AH.$209.met1 AH.$92.li1 9.3
Rext_192 AH.$210.met1 AH.$94.li1 9.3
Rext_193 AH.$211.met1 AH.$236.met2 4.5
Rext_194 AH.$212.met1 AH.$214.met1 0.0298913043478
Rext_195 AH.$212.met1 AH.$96.li1 9.3
Rext_196 AH.$213.met1 AH.$216.met1 0.195652173913
Rext_197 AH.$213.met1 AH.$98.li1 9.3
Rext_198 AH.$214.met1 AH.$215.met1 0.165760869565
Rext_199 AH.$214.met1 AH.$238.met2 4.5
Rext_200 AH.$215.met1 AH.$217.met1 0.195652173913
Rext_201 AH.$216.met1 AH.$218.met1 0.195652173913
Rext_202 AH.$217.met1 AH.$219.met1 0.195652173913
Rext_203 AH.$218.met1 AH.$220.met1 0.195652173913
Rext_204 AH.$219.met1 AH.$221.met1 0.195652173913
Rext_205 AH.$220.met1 AH.$222.met1 0.195652173913
Rext_206 AH.$221.met1 AH.$223.met1 0.195652173913
Rext_207 AH.$222.met1 AH.$224.met1 0.195652173913
Rext_208 AH.$223.met1 AH.$225.met1 0.195652173913
Rext_209 AH.$224.met1 AH.$226.met1 0.195652173913
Rext_210 AH.$225.met1 AH.$227.met1 0.195652173913
Rext_211 AH.$226.met1 AH.$228.met1 0.195652173913
Rext_212 AH.$227.met1 AH.$229.met1 0.195652173913
Rext_213 AH.$228.met1 AH.$230.met1 0.195652173913
Rext_214 AH.$229.met1 AH.$231.met1 0.195652173913
Rext_215 AH.$230.met1 AH.$232.met1 0.195652173913
Rext_216 AH.$231.met1 AH.$233.met1 0.195652173913
Rext_217 AH.$232.met1 AH.$234.met1 0.195652173913
Rext_218 AH.$235.met2 AH.$237.met2 4.24341755547
Rext_219 AH.$237.met2 AH.$238.met2 0.34081714793
Rext_220 AH.$239.poly AH.$240.poly 16.2961904762
Rext_221 AH.$240.poly AH.P1.poly 8.1480952381
Rext_222 AH.$241.poly AH.$242.poly 16.2961904762
Rext_223 AH.$241.poly AH.P1.poly 8.1480952381
Rext_224 AH.$242.poly AH.$3.li1 11.56
Rext_225 AH.$243.poly AH.$96.li1 152
Rext_226 AH.$243.poly AH.P0.poly 100.79825
Rext_227 AH.$244.poly AH.$98.li1 152
Rext_228 AH.$244.poly AH.P0.poly 100.79825
Rext_229 AH.$52.li1 AH.$54.li1 27.1058823529
Rext_230 AH.$52.li1 AH.P0.psdm 585
Rext_231 AH.$54.li1 AH.$56.li1 27.1058823529
Rext_232 AH.$54.li1 AH.P0.psdm 585
Rext_233 AH.$56.li1 AH.$58.li1 27.1058823529
Rext_234 AH.$56.li1 AH.P0.psdm 585
Rext_235 AH.$58.li1 AH.$60.li1 27.1058823529
Rext_236 AH.$58.li1 AH.P0.psdm 585
Rext_237 AH.$60.li1 AH.$62.li1 27.1058823529
Rext_238 AH.$60.li1 AH.P0.psdm 585
Rext_239 AH.$62.li1 AH.$64.li1 27.1058823529
Rext_240 AH.$62.li1 AH.P0.psdm 585
Rext_241 AH.$64.li1 AH.$66.li1 27.1058823529
Rext_242 AH.$64.li1 AH.P0.psdm 585
Rext_243 AH.$66.li1 AH.$68.li1 27.1058823529
Rext_244 AH.$66.li1 AH.P0.psdm 585
Rext_245 AH.$68.li1 AH.$70.li1 27.1058823529
Rext_246 AH.$68.li1 AH.P0.psdm 585
Rext_247 AH.$70.li1 AH.$72.li1 27.1058823529
Rext_248 AH.$70.li1 AH.P0.psdm 585
Rext_249 AH.$72.li1 AH.$74.li1 27.1058823529
Rext_250 AH.$72.li1 AH.P0.psdm 585
Rext_251 AH.$74.li1 AH.$76.li1 27.1058823529
Rext_252 AH.$74.li1 AH.P0.psdm 585
Rext_253 AH.$76.li1 AH.$78.li1 27.1058823529
Rext_254 AH.$76.li1 AH.P0.psdm 585
Rext_255 AH.$78.li1 AH.$80.li1 27.1058823529
Rext_256 AH.$78.li1 AH.P0.psdm 585
Rext_257 AH.$80.li1 AH.$82.li1 27.1058823529
Rext_258 AH.$80.li1 AH.P0.psdm 585
Rext_259 AH.$82.li1 AH.$84.li1 27.1058823529
Rext_260 AH.$82.li1 AH.P0.psdm 585
Rext_261 AH.$84.li1 AH.$86.li1 27.1058823529
Rext_262 AH.$84.li1 AH.P0.psdm 585
Rext_263 AH.$86.li1 AH.$88.li1 27.1058823529
Rext_264 AH.$86.li1 AH.P0.psdm 585
Rext_265 AH.$88.li1 AH.$90.li1 27.1058823529
Rext_266 AH.$88.li1 AH.P0.psdm 585
Rext_267 AH.$90.li1 AH.$92.li1 27.1058823529
Rext_268 AH.$90.li1 AH.P0.psdm 585
Rext_269 AH.$92.li1 AH.$94.li1 27.1058823529
Rext_270 AH.$92.li1 AH.P0.psdm 585
Rext_271 AH.$94.li1 AH.P0.psdm 585
Rext_272 B B.$118.met2 0.003125
Rext_273 B B.$120.met3 3.41
Rext_274 B.$0.li1 B.$12.li1 1.15555555556
Rext_275 B.$0.li1 B.$121.poly 11.56
Rext_276 B.$0.li1 B.$13.li1 0.977777777778
Rext_277 B.$1.li1 B.$122.poly 11.56
Rext_278 B.$1.li1 B.$14.li1 1.0962962963
Rext_279 B.$1.li1 B.$15.li1 1.03703703704
Rext_280 B.$10.li1 B.$106.met1 1.55
Rext_281 B.$10.li1 B.$17.li1 2.13333333333
Rext_282 B.$10.li1 B.$3.li1 0.977777777778
Rext_283 B.$100.met1 B.$12.li1 1.55
Rext_284 B.$100.met1 B.$75.met1 0.0139548693587
Rext_285 B.$101.met1 B.$102.met1 0.021377672209
Rext_286 B.$101.met1 B.$13.li1 1.55
Rext_287 B.$101.met1 B.$75.met1 0.00742280285036
Rext_288 B.$102.met1 B.$103.met1 0.021377672209
Rext_289 B.$102.met1 B.$14.li1 1.55
Rext_290 B.$103.met1 B.$104.met1 0.021377672209
Rext_291 B.$103.met1 B.$15.li1 1.55
Rext_292 B.$104.met1 B.$105.met1 0.021377672209
Rext_293 B.$104.met1 B.$16.li1 1.55
Rext_294 B.$105.met1 B.$106.met1 0.021377672209
Rext_295 B.$105.met1 B.$17.li1 1.55
Rext_296 B.$106.met1 B.$107.met1 0.021377672209
Rext_297 B.$107.met1 B.$11.li1 1.55
Rext_298 B.$108.met1 B.$109.met1 0.18
Rext_299 B.$108.met1 B.$53.li1 9.3
Rext_300 B.$109.met1 B.$110.met1 0.1275
Rext_301 B.$109.met1 B.$54.li1 9.3
Rext_302 B.$11.li1 B.$3.li1 1.15555555556
Rext_303 B.$110.met1 B.$111.met1 0.02734375
Rext_304 B.$110.met1 B.$118.met2 4.5
Rext_305 B.$111.met1 B.$112.met1 0.17015625
Rext_306 B.$111.met1 B.$55.li1 9.3
Rext_307 B.$112.met1 B.$113.met1 0.18
Rext_308 B.$112.met1 B.$56.li1 9.3
Rext_309 B.$113.met1 B.$114.met1 0.18
Rext_310 B.$113.met1 B.$57.li1 9.3
Rext_311 B.$114.met1 B.$58.li1 9.3
Rext_312 B.$115.met2 B.$116.met2 0.0046875
Rext_313 B.$115.met2 B.$119.met3 3.41
Rext_314 B.$116.met2 B.$75.met1 4.5
Rext_315 B.$119.met3 B.$120.met3 3.06675
Rext_316 B.$121.poly B.$122.poly 16.2961904762
Rext_317 B.$122.poly B.P1.poly 8.1480952381
Rext_318 B.$123.poly B.$124.poly 16.2961904762
Rext_319 B.$123.poly B.$2.li1 11.56
Rext_320 B.$123.poly B.P1.poly 8.1480952381
Rext_321 B.$124.poly B.$3.li1 11.56
Rext_322 B.$125.poly B.$52.li1 11.56
Rext_323 B.$125.poly B.P0.poly 4.13142857143
Rext_324 B.$13.li1 B.$14.li1 2.13333333333
Rext_325 B.$15.li1 B.$16.li1 2.13333333333
Rext_326 B.$16.li1 B.$2.li1 1.03703703704
Rext_327 B.$17.li1 B.$2.li1 1.0962962963
Rext_328 B.$52.li1 B.$55.li1 6.58285714286
Rext_329 B.$52.li1 B.$56.li1 6.58285714286
Rext_330 B.$53.li1 B.$54.li1 13.1657142857
Rext_331 B.$54.li1 B.$55.li1 13.1657142857
Rext_332 B.$56.li1 B.$57.li1 13.1657142857
Rext_333 B.$57.li1 B.$58.li1 13.1657142857
Rext_334 BH BH.$240.met2 0.0705882352941
Rext_335 BH BH.$242.met3 3.41
Rext_336 BH.$0.li1 BH.$16.li1 1.15555555556
Rext_337 BH.$0.li1 BH.$17.li1 0.977777777778
Rext_338 BH.$0.li1 BH.$243.poly 11.56
Rext_339 BH.$1.li1 BH.$18.li1 1.0962962963
Rext_340 BH.$1.li1 BH.$19.li1 1.03703703704
Rext_341 BH.$1.li1 BH.$244.poly 11.56
Rext_342 BH.$10.li1 BH.$146.met1 1.55
Rext_343 BH.$10.li1 BH.$21.li1 2.13333333333
Rext_344 BH.$10.li1 BH.$3.li1 0.977777777778
Rext_345 BH.$100.li1 BH.$102.li1 27.1058823529
Rext_346 BH.$100.li1 BH.$215.met1 9.3
Rext_347 BH.$100.li1 BH.$98.li1 27.1058823529
Rext_348 BH.$100.li1 BH.P0.psdm 585
Rext_349 BH.$102.li1 BH.$104.li1 27.1058823529
Rext_350 BH.$102.li1 BH.$216.met1 9.3
Rext_351 BH.$102.li1 BH.P0.psdm 585
Rext_352 BH.$104.li1 BH.$106.li1 27.1058823529
Rext_353 BH.$104.li1 BH.$217.met1 9.3
Rext_354 BH.$104.li1 BH.P0.psdm 585
Rext_355 BH.$106.li1 BH.$108.li1 27.1058823529
Rext_356 BH.$106.li1 BH.$218.met1 9.3
Rext_357 BH.$106.li1 BH.P0.psdm 585
Rext_358 BH.$108.li1 BH.$110.li1 27.1058823529
Rext_359 BH.$108.li1 BH.$219.met1 9.3
Rext_360 BH.$108.li1 BH.P0.psdm 585
Rext_361 BH.$11.li1 BH.$147.met1 1.55
Rext_362 BH.$11.li1 BH.$3.li1 1.15555555556
Rext_363 BH.$110.li1 BH.$112.li1 27.1058823529
Rext_364 BH.$110.li1 BH.$220.met1 9.3
Rext_365 BH.$110.li1 BH.P0.psdm 585
Rext_366 BH.$112.li1 BH.$114.li1 27.1058823529
Rext_367 BH.$112.li1 BH.$221.met1 9.3
Rext_368 BH.$112.li1 BH.P0.psdm 585
Rext_369 BH.$114.li1 BH.$116.li1 27.1058823529
Rext_370 BH.$114.li1 BH.$222.met1 9.3
Rext_371 BH.$114.li1 BH.P0.psdm 585
Rext_372 BH.$116.li1 BH.$118.li1 27.1058823529
Rext_373 BH.$116.li1 BH.$223.met1 9.3
Rext_374 BH.$116.li1 BH.P0.psdm 585
Rext_375 BH.$118.li1 BH.$120.li1 27.1058823529
Rext_376 BH.$118.li1 BH.$224.met1 9.3
Rext_377 BH.$118.li1 BH.P0.psdm 585
Rext_378 BH.$12.li1 BH.$148.met1 9.3
Rext_379 BH.$12.li1 BH.$24.li1 27.1058823529
Rext_380 BH.$12.li1 BH.$247.poly 152
Rext_381 BH.$120.li1 BH.$122.li1 27.1058823529
Rext_382 BH.$120.li1 BH.$225.met1 9.3
Rext_383 BH.$120.li1 BH.P0.psdm 585
Rext_384 BH.$122.li1 BH.$124.li1 27.1058823529
Rext_385 BH.$122.li1 BH.$226.met1 9.3
Rext_386 BH.$122.li1 BH.P0.psdm 585
Rext_387 BH.$124.li1 BH.$126.li1 27.1058823529
Rext_388 BH.$124.li1 BH.$227.met1 9.3
Rext_389 BH.$124.li1 BH.P0.psdm 585
Rext_390 BH.$126.li1 BH.$128.li1 27.1058823529
Rext_391 BH.$126.li1 BH.$228.met1 9.3
Rext_392 BH.$126.li1 BH.P0.psdm 585
Rext_393 BH.$128.li1 BH.$130.li1 27.1058823529
Rext_394 BH.$128.li1 BH.$229.met1 9.3
Rext_395 BH.$128.li1 BH.P0.psdm 585
Rext_396 BH.$130.li1 BH.$132.li1 27.1058823529
Rext_397 BH.$130.li1 BH.$230.met1 9.3
Rext_398 BH.$130.li1 BH.P0.psdm 585
Rext_399 BH.$132.li1 BH.$134.li1 27.1058823529
Rext_400 BH.$132.li1 BH.$231.met1 9.3
Rext_401 BH.$132.li1 BH.P0.psdm 585
Rext_402 BH.$134.li1 BH.$136.li1 27.1058823529
Rext_403 BH.$134.li1 BH.$232.met1 9.3
Rext_404 BH.$134.li1 BH.P0.psdm 585
Rext_405 BH.$136.li1 BH.$138.li1 27.1058823529
Rext_406 BH.$136.li1 BH.$233.met1 9.3
Rext_407 BH.$136.li1 BH.P0.psdm 585
Rext_408 BH.$138.li1 BH.$234.met1 9.3
Rext_409 BH.$138.li1 BH.P0.psdm 585
Rext_410 BH.$14.li1 BH.$149.met1 9.3
Rext_411 BH.$14.li1 BH.$248.poly 152
Rext_412 BH.$14.li1 BH.$26.li1 27.1058823529
Rext_413 BH.$140.met1 BH.$16.li1 1.55
Rext_414 BH.$140.met1 BH.$160.met1 0.0139548693587
Rext_415 BH.$141.met1 BH.$142.met1 0.021377672209
Rext_416 BH.$141.met1 BH.$160.met1 0.00742280285036
Rext_417 BH.$141.met1 BH.$17.li1 1.55
Rext_418 BH.$142.met1 BH.$143.met1 0.021377672209
Rext_419 BH.$142.met1 BH.$18.li1 1.55
Rext_420 BH.$143.met1 BH.$144.met1 0.021377672209
Rext_421 BH.$143.met1 BH.$19.li1 1.55
Rext_422 BH.$144.met1 BH.$145.met1 0.021377672209
Rext_423 BH.$144.met1 BH.$20.li1 1.55
Rext_424 BH.$145.met1 BH.$146.met1 0.021377672209
Rext_425 BH.$145.met1 BH.$21.li1 1.55
Rext_426 BH.$146.met1 BH.$147.met1 0.021377672209
Rext_427 BH.$148.met1 BH.$161.met1 0.192934782609
Rext_428 BH.$149.met1 BH.$159.met1 0.195652173913
Rext_429 BH.$158.met1 BH.$161.met1 0.00271739130435
Rext_430 BH.$158.met1 BH.$170.met1 0.195652173913
Rext_431 BH.$158.met1 BH.$24.li1 9.3
Rext_432 BH.$159.met1 BH.$171.met1 0.195652173913
Rext_433 BH.$159.met1 BH.$26.li1 9.3
Rext_434 BH.$160.met1 BH.$237.met2 4.5
Rext_435 BH.$161.met1 BH.$238.met2 4.5
Rext_436 BH.$17.li1 BH.$18.li1 2.13333333333
Rext_437 BH.$170.met1 BH.$180.met1 0.195652173913
Rext_438 BH.$170.met1 BH.$36.li1 9.3
Rext_439 BH.$171.met1 BH.$181.met1 0.195652173913
Rext_440 BH.$171.met1 BH.$38.li1 9.3
Rext_441 BH.$180.met1 BH.$190.met1 0.195652173913
Rext_442 BH.$180.met1 BH.$48.li1 9.3
Rext_443 BH.$181.met1 BH.$191.met1 0.195652173913
Rext_444 BH.$181.met1 BH.$50.li1 9.3
Rext_445 BH.$19.li1 BH.$20.li1 2.13333333333
Rext_446 BH.$190.met1 BH.$200.met1 0.195652173913
Rext_447 BH.$190.met1 BH.$60.li1 9.3
Rext_448 BH.$191.met1 BH.$201.met1 0.195652173913
Rext_449 BH.$191.met1 BH.$62.li1 9.3
Rext_450 BH.$2.li1 BH.$20.li1 1.03703703704
Rext_451 BH.$2.li1 BH.$21.li1 1.0962962963
Rext_452 BH.$2.li1 BH.$245.poly 11.56
Rext_453 BH.$200.met1 BH.$202.met1 0.195652173913
Rext_454 BH.$200.met1 BH.$72.li1 9.3
Rext_455 BH.$201.met1 BH.$203.met1 0.195652173913
Rext_456 BH.$201.met1 BH.$74.li1 9.3
Rext_457 BH.$202.met1 BH.$204.met1 0.195652173913
Rext_458 BH.$202.met1 BH.$76.li1 9.3
Rext_459 BH.$203.met1 BH.$205.met1 0.195652173913
Rext_460 BH.$203.met1 BH.$78.li1 9.3
Rext_461 BH.$204.met1 BH.$206.met1 0.195652173913
Rext_462 BH.$204.met1 BH.$80.li1 9.3
Rext_463 BH.$205.met1 BH.$207.met1 0.195652173913
Rext_464 BH.$205.met1 BH.$82.li1 9.3
Rext_465 BH.$206.met1 BH.$208.met1 0.195652173913
Rext_466 BH.$206.met1 BH.$84.li1 9.3
Rext_467 BH.$207.met1 BH.$209.met1 0.195652173913
Rext_468 BH.$207.met1 BH.$86.li1 9.3
Rext_469 BH.$208.met1 BH.$210.met1 0.195652173913
Rext_470 BH.$208.met1 BH.$88.li1 9.3
Rext_471 BH.$209.met1 BH.$211.met1 0.195652173913
Rext_472 BH.$209.met1 BH.$90.li1 9.3
Rext_473 BH.$210.met1 BH.$92.li1 9.3
Rext_474 BH.$211.met1 BH.$94.li1 9.3
Rext_475 BH.$212.met1 BH.$213.met1 0.0298913043478
Rext_476 BH.$212.met1 BH.$214.met1 0.165760869565
Rext_477 BH.$212.met1 BH.$240.met2 4.5
Rext_478 BH.$213.met1 BH.$96.li1 9.3
Rext_479 BH.$214.met1 BH.$215.met1 0.195652173913
Rext_480 BH.$214.met1 BH.$98.li1 9.3
Rext_481 BH.$215.met1 BH.$216.met1 0.195652173913
Rext_482 BH.$216.met1 BH.$217.met1 0.195652173913
Rext_483 BH.$217.met1 BH.$218.met1 0.195652173913
Rext_484 BH.$218.met1 BH.$219.met1 0.195652173913
Rext_485 BH.$219.met1 BH.$220.met1 0.195652173913
Rext_486 BH.$220.met1 BH.$221.met1 0.195652173913
Rext_487 BH.$221.met1 BH.$222.met1 0.195652173913
Rext_488 BH.$222.met1 BH.$223.met1 0.195652173913
Rext_489 BH.$223.met1 BH.$224.met1 0.195652173913
Rext_490 BH.$224.met1 BH.$225.met1 0.195652173913
Rext_491 BH.$225.met1 BH.$226.met1 0.195652173913
Rext_492 BH.$226.met1 BH.$227.met1 0.195652173913
Rext_493 BH.$227.met1 BH.$228.met1 0.195652173913
Rext_494 BH.$228.met1 BH.$229.met1 0.195652173913
Rext_495 BH.$229.met1 BH.$230.met1 0.195652173913
Rext_496 BH.$230.met1 BH.$231.met1 0.195652173913
Rext_497 BH.$231.met1 BH.$232.met1 0.195652173913
Rext_498 BH.$232.met1 BH.$233.met1 0.195652173913
Rext_499 BH.$233.met1 BH.$234.met1 0.195652173913
Rext_500 BH.$235.met2 BH.$236.met2 6.98216755198
Rext_501 BH.$235.met2 BH.$237.met2 4.57814312291
Rext_502 BH.$235.met2 BH.$238.met2 0.0800754367486
Rext_503 BH.$236.met2 BH.$241.met3 3.41
Rext_504 BH.$24.li1 BH.$247.poly 152
Rext_505 BH.$24.li1 BH.$36.li1 27.1058823529
Rext_506 BH.$241.met3 BH.$242.met3 1.16325
Rext_507 BH.$243.poly BH.$244.poly 16.2961904762
Rext_508 BH.$244.poly BH.P1.poly 8.1480952381
Rext_509 BH.$245.poly BH.$246.poly 16.2961904762
Rext_510 BH.$245.poly BH.P1.poly 8.1480952381
Rext_511 BH.$246.poly BH.$3.li1 11.56
Rext_512 BH.$247.poly BH.$36.li1 152
Rext_513 BH.$247.poly BH.$48.li1 152
Rext_514 BH.$247.poly BH.$60.li1 152
Rext_515 BH.$247.poly BH.$72.li1 152
Rext_516 BH.$247.poly BH.$76.li1 152
Rext_517 BH.$247.poly BH.$80.li1 152
Rext_518 BH.$247.poly BH.$84.li1 152
Rext_519 BH.$247.poly BH.$88.li1 152
Rext_520 BH.$247.poly BH.$92.li1 152
Rext_521 BH.$247.poly BH.P0.poly 100.79825
Rext_522 BH.$248.poly BH.$26.li1 152
Rext_523 BH.$248.poly BH.$38.li1 152
Rext_524 BH.$248.poly BH.$50.li1 152
Rext_525 BH.$248.poly BH.$62.li1 152
Rext_526 BH.$248.poly BH.$74.li1 152
Rext_527 BH.$248.poly BH.$78.li1 152
Rext_528 BH.$248.poly BH.$82.li1 152
Rext_529 BH.$248.poly BH.$86.li1 152
Rext_530 BH.$248.poly BH.$90.li1 152
Rext_531 BH.$248.poly BH.$94.li1 152
Rext_532 BH.$248.poly BH.P0.poly 100.79825
Rext_533 BH.$26.li1 BH.$38.li1 27.1058823529
Rext_534 BH.$36.li1 BH.$48.li1 27.1058823529
Rext_535 BH.$38.li1 BH.$50.li1 27.1058823529
Rext_536 BH.$48.li1 BH.$60.li1 27.1058823529
Rext_537 BH.$50.li1 BH.$62.li1 27.1058823529
Rext_538 BH.$60.li1 BH.$72.li1 27.1058823529
Rext_539 BH.$62.li1 BH.$74.li1 27.1058823529
Rext_540 BH.$72.li1 BH.$76.li1 27.1058823529
Rext_541 BH.$74.li1 BH.$78.li1 27.1058823529
Rext_542 BH.$76.li1 BH.$80.li1 27.1058823529
Rext_543 BH.$78.li1 BH.$82.li1 27.1058823529
Rext_544 BH.$80.li1 BH.$84.li1 27.1058823529
Rext_545 BH.$82.li1 BH.$86.li1 27.1058823529
Rext_546 BH.$84.li1 BH.$88.li1 27.1058823529
Rext_547 BH.$86.li1 BH.$90.li1 27.1058823529
Rext_548 BH.$88.li1 BH.$92.li1 27.1058823529
Rext_549 BH.$90.li1 BH.$94.li1 27.1058823529
Rext_550 BH.$96.li1 BH.$98.li1 27.1058823529
Rext_551 BH.$96.li1 BH.P0.psdm 585
Rext_552 BH.$98.li1 BH.P0.psdm 585
Rext_553 N1 N1.$301.met2 0.128783602538
Rext_554 N1 N1.$302.met2 0.335851825208
Rext_555 N1.$0.li1 N1.$198.met1 9.3
Rext_556 N1.$0.li1 N1.$2.li1 27.1058823529
Rext_557 N1.$0.li1 N1.P0.nsdm 185
Rext_558 N1.$10.li1 N1.$12.li1 27.1058823529
Rext_559 N1.$10.li1 N1.$203.met1 9.3
Rext_560 N1.$10.li1 N1.$8.li1 27.1058823529
Rext_561 N1.$10.li1 N1.P0.nsdm 185
Rext_562 N1.$100.li1 N1.$104.li1 27.1058823529
Rext_563 N1.$100.li1 N1.$250.met1 9.3
Rext_564 N1.$100.li1 N1.$354.poly 152
Rext_565 N1.$100.li1 N1.$96.li1 27.1058823529
Rext_566 N1.$102.li1 N1.$106.li1 27.1058823529
Rext_567 N1.$102.li1 N1.$251.met1 9.3
Rext_568 N1.$102.li1 N1.$355.poly 152
Rext_569 N1.$102.li1 N1.$98.li1 27.1058823529
Rext_570 N1.$104.li1 N1.$108.li1 27.1058823529
Rext_571 N1.$104.li1 N1.$252.met1 9.3
Rext_572 N1.$104.li1 N1.$354.poly 152
Rext_573 N1.$106.li1 N1.$110.li1 27.1058823529
Rext_574 N1.$106.li1 N1.$253.met1 9.3
Rext_575 N1.$106.li1 N1.$355.poly 152
Rext_576 N1.$108.li1 N1.$112.li1 27.1058823529
Rext_577 N1.$108.li1 N1.$254.met1 9.3
Rext_578 N1.$108.li1 N1.$354.poly 152
Rext_579 N1.$110.li1 N1.$114.li1 27.1058823529
Rext_580 N1.$110.li1 N1.$255.met1 9.3
Rext_581 N1.$110.li1 N1.$355.poly 152
Rext_582 N1.$112.li1 N1.$116.li1 27.1058823529
Rext_583 N1.$112.li1 N1.$256.met1 9.3
Rext_584 N1.$112.li1 N1.$354.poly 152
Rext_585 N1.$114.li1 N1.$118.li1 27.1058823529
Rext_586 N1.$114.li1 N1.$257.met1 9.3
Rext_587 N1.$114.li1 N1.$355.poly 152
Rext_588 N1.$116.li1 N1.$120.li1 27.1058823529
Rext_589 N1.$116.li1 N1.$258.met1 9.3
Rext_590 N1.$116.li1 N1.$354.poly 152
Rext_591 N1.$118.li1 N1.$122.li1 27.1058823529
Rext_592 N1.$118.li1 N1.$259.met1 9.3
Rext_593 N1.$118.li1 N1.$355.poly 152
Rext_594 N1.$12.li1 N1.$14.li1 27.1058823529
Rext_595 N1.$12.li1 N1.$204.met1 9.3
Rext_596 N1.$12.li1 N1.P0.nsdm 185
Rext_597 N1.$120.li1 N1.$124.li1 27.1058823529
Rext_598 N1.$120.li1 N1.$260.met1 9.3
Rext_599 N1.$120.li1 N1.$354.poly 152
Rext_600 N1.$122.li1 N1.$126.li1 27.1058823529
Rext_601 N1.$122.li1 N1.$261.met1 9.3
Rext_602 N1.$122.li1 N1.$355.poly 152
Rext_603 N1.$124.li1 N1.$128.li1 27.1058823529
Rext_604 N1.$124.li1 N1.$262.met1 9.3
Rext_605 N1.$124.li1 N1.$354.poly 152
Rext_606 N1.$126.li1 N1.$130.li1 27.1058823529
Rext_607 N1.$126.li1 N1.$263.met1 9.3
Rext_608 N1.$126.li1 N1.$355.poly 152
Rext_609 N1.$128.li1 N1.$264.met1 9.3
Rext_610 N1.$128.li1 N1.$354.poly 152
Rext_611 N1.$130.li1 N1.$265.met1 9.3
Rext_612 N1.$130.li1 N1.$355.poly 152
Rext_613 N1.$132.li1 N1.$134.li1 27.1058823529
Rext_614 N1.$132.li1 N1.$267.met1 9.3
Rext_615 N1.$132.li1 N1.P0.psdm 585
Rext_616 N1.$134.li1 N1.$136.li1 27.1058823529
Rext_617 N1.$134.li1 N1.$268.met1 9.3
Rext_618 N1.$134.li1 N1.P0.psdm 585
Rext_619 N1.$136.li1 N1.$138.li1 27.1058823529
Rext_620 N1.$136.li1 N1.$269.met1 9.3
Rext_621 N1.$136.li1 N1.P0.psdm 585
Rext_622 N1.$138.li1 N1.$140.li1 27.1058823529
Rext_623 N1.$138.li1 N1.$270.met1 9.3
Rext_624 N1.$138.li1 N1.P0.psdm 585
Rext_625 N1.$14.li1 N1.$16.li1 27.1058823529
Rext_626 N1.$14.li1 N1.$205.met1 9.3
Rext_627 N1.$14.li1 N1.P0.nsdm 185
Rext_628 N1.$140.li1 N1.$142.li1 27.1058823529
Rext_629 N1.$140.li1 N1.$271.met1 9.3
Rext_630 N1.$140.li1 N1.P0.psdm 585
Rext_631 N1.$142.li1 N1.$144.li1 27.1058823529
Rext_632 N1.$142.li1 N1.$272.met1 9.3
Rext_633 N1.$142.li1 N1.P0.psdm 585
Rext_634 N1.$144.li1 N1.$146.li1 27.1058823529
Rext_635 N1.$144.li1 N1.$273.met1 9.3
Rext_636 N1.$144.li1 N1.P0.psdm 585
Rext_637 N1.$146.li1 N1.$148.li1 27.1058823529
Rext_638 N1.$146.li1 N1.$274.met1 9.3
Rext_639 N1.$146.li1 N1.P0.psdm 585
Rext_640 N1.$148.li1 N1.$150.li1 27.1058823529
Rext_641 N1.$148.li1 N1.$275.met1 9.3
Rext_642 N1.$148.li1 N1.P0.psdm 585
Rext_643 N1.$150.li1 N1.$152.li1 27.1058823529
Rext_644 N1.$150.li1 N1.$276.met1 9.3
Rext_645 N1.$150.li1 N1.P0.psdm 585
Rext_646 N1.$152.li1 N1.$277.met1 9.3
Rext_647 N1.$152.li1 N1.P0.psdm 585
Rext_648 N1.$154.li1 N1.$158.li1 27.1058823529
Rext_649 N1.$154.li1 N1.$278.met1 9.3
Rext_650 N1.$154.li1 N1.$376.poly 152
Rext_651 N1.$156.li1 N1.$160.li1 27.1058823529
Rext_652 N1.$156.li1 N1.$279.met1 9.3
Rext_653 N1.$156.li1 N1.$377.poly 152
Rext_654 N1.$158.li1 N1.$162.li1 27.1058823529
Rext_655 N1.$158.li1 N1.$281.met1 9.3
Rext_656 N1.$158.li1 N1.$376.poly 152
Rext_657 N1.$16.li1 N1.$18.li1 27.1058823529
Rext_658 N1.$16.li1 N1.$206.met1 9.3
Rext_659 N1.$16.li1 N1.P0.nsdm 185
Rext_660 N1.$160.li1 N1.$164.li1 27.1058823529
Rext_661 N1.$160.li1 N1.$282.met1 9.3
Rext_662 N1.$160.li1 N1.$377.poly 152
Rext_663 N1.$162.li1 N1.$166.li1 27.1058823529
Rext_664 N1.$162.li1 N1.$283.met1 9.3
Rext_665 N1.$162.li1 N1.$376.poly 152
Rext_666 N1.$164.li1 N1.$168.li1 27.1058823529
Rext_667 N1.$164.li1 N1.$284.met1 9.3
Rext_668 N1.$164.li1 N1.$377.poly 152
Rext_669 N1.$166.li1 N1.$170.li1 27.1058823529
Rext_670 N1.$166.li1 N1.$285.met1 9.3
Rext_671 N1.$166.li1 N1.$376.poly 152
Rext_672 N1.$168.li1 N1.$172.li1 27.1058823529
Rext_673 N1.$168.li1 N1.$286.met1 9.3
Rext_674 N1.$168.li1 N1.$377.poly 152
Rext_675 N1.$170.li1 N1.$174.li1 27.1058823529
Rext_676 N1.$170.li1 N1.$287.met1 9.3
Rext_677 N1.$170.li1 N1.$376.poly 152
Rext_678 N1.$172.li1 N1.$176.li1 27.1058823529
Rext_679 N1.$172.li1 N1.$288.met1 9.3
Rext_680 N1.$172.li1 N1.$377.poly 152
Rext_681 N1.$174.li1 N1.$178.li1 27.1058823529
Rext_682 N1.$174.li1 N1.$289.met1 9.3
Rext_683 N1.$174.li1 N1.$376.poly 152
Rext_684 N1.$176.li1 N1.$180.li1 27.1058823529
Rext_685 N1.$176.li1 N1.$290.met1 9.3
Rext_686 N1.$176.li1 N1.$377.poly 152
Rext_687 N1.$178.li1 N1.$182.li1 27.1058823529
Rext_688 N1.$178.li1 N1.$291.met1 9.3
Rext_689 N1.$178.li1 N1.$376.poly 152
Rext_690 N1.$18.li1 N1.$20.li1 27.1058823529
Rext_691 N1.$18.li1 N1.$207.met1 9.3
Rext_692 N1.$18.li1 N1.P0.nsdm 185
Rext_693 N1.$180.li1 N1.$184.li1 27.1058823529
Rext_694 N1.$180.li1 N1.$292.met1 9.3
Rext_695 N1.$180.li1 N1.$377.poly 152
Rext_696 N1.$182.li1 N1.$186.li1 27.1058823529
Rext_697 N1.$182.li1 N1.$293.met1 9.3
Rext_698 N1.$182.li1 N1.$376.poly 152
Rext_699 N1.$184.li1 N1.$188.li1 27.1058823529
Rext_700 N1.$184.li1 N1.$294.met1 9.3
Rext_701 N1.$184.li1 N1.$377.poly 152
Rext_702 N1.$186.li1 N1.$190.li1 27.1058823529
Rext_703 N1.$186.li1 N1.$295.met1 9.3
Rext_704 N1.$186.li1 N1.$376.poly 152
Rext_705 N1.$188.li1 N1.$192.li1 27.1058823529
Rext_706 N1.$188.li1 N1.$296.met1 9.3
Rext_707 N1.$188.li1 N1.$377.poly 152
Rext_708 N1.$190.li1 N1.$194.li1 27.1058823529
Rext_709 N1.$190.li1 N1.$297.met1 9.3
Rext_710 N1.$190.li1 N1.$376.poly 152
Rext_711 N1.$192.li1 N1.$196.li1 27.1058823529
Rext_712 N1.$192.li1 N1.$298.met1 9.3
Rext_713 N1.$192.li1 N1.$377.poly 152
Rext_714 N1.$194.li1 N1.$299.met1 9.3
Rext_715 N1.$194.li1 N1.$376.poly 152
Rext_716 N1.$196.li1 N1.$300.met1 9.3
Rext_717 N1.$196.li1 N1.$377.poly 152
Rext_718 N1.$198.met1 N1.$242.met1 0.165760869565
Rext_719 N1.$199.met1 N1.$2.li1 9.3
Rext_720 N1.$199.met1 N1.$200.met1 0.195652173913
Rext_721 N1.$199.met1 N1.$242.met1 0.0298913043478
Rext_722 N1.$2.li1 N1.$4.li1 27.1058823529
Rext_723 N1.$2.li1 N1.P0.nsdm 185
Rext_724 N1.$20.li1 N1.$208.met1 9.3
Rext_725 N1.$20.li1 N1.$22.li1 27.1058823529
Rext_726 N1.$20.li1 N1.P0.nsdm 185
Rext_727 N1.$200.met1 N1.$201.met1 0.195652173913
Rext_728 N1.$200.met1 N1.$4.li1 9.3
Rext_729 N1.$201.met1 N1.$202.met1 0.195652173913
Rext_730 N1.$201.met1 N1.$6.li1 9.3
Rext_731 N1.$202.met1 N1.$203.met1 0.195652173913
Rext_732 N1.$202.met1 N1.$8.li1 9.3
Rext_733 N1.$203.met1 N1.$204.met1 0.195652173913
Rext_734 N1.$204.met1 N1.$205.met1 0.195652173913
Rext_735 N1.$205.met1 N1.$206.met1 0.195652173913
Rext_736 N1.$206.met1 N1.$207.met1 0.195652173913
Rext_737 N1.$207.met1 N1.$208.met1 0.195652173913
Rext_738 N1.$208.met1 N1.$209.met1 0.195652173913
Rext_739 N1.$209.met1 N1.$210.met1 0.195652173913
Rext_740 N1.$209.met1 N1.$22.li1 9.3
Rext_741 N1.$210.met1 N1.$211.met1 0.195652173913
Rext_742 N1.$210.met1 N1.$24.li1 9.3
Rext_743 N1.$211.met1 N1.$212.met1 0.195652173913
Rext_744 N1.$211.met1 N1.$26.li1 9.3
Rext_745 N1.$212.met1 N1.$213.met1 0.195652173913
Rext_746 N1.$212.met1 N1.$28.li1 9.3
Rext_747 N1.$213.met1 N1.$214.met1 0.195652173913
Rext_748 N1.$213.met1 N1.$30.li1 9.3
Rext_749 N1.$214.met1 N1.$215.met1 0.195652173913
Rext_750 N1.$214.met1 N1.$32.li1 9.3
Rext_751 N1.$215.met1 N1.$216.met1 0.195652173913
Rext_752 N1.$215.met1 N1.$34.li1 9.3
Rext_753 N1.$216.met1 N1.$217.met1 0.195652173913
Rext_754 N1.$216.met1 N1.$36.li1 9.3
Rext_755 N1.$217.met1 N1.$218.met1 0.195652173913
Rext_756 N1.$217.met1 N1.$38.li1 9.3
Rext_757 N1.$218.met1 N1.$219.met1 0.195652173913
Rext_758 N1.$218.met1 N1.$40.li1 9.3
Rext_759 N1.$219.met1 N1.$220.met1 0.195652173913
Rext_760 N1.$219.met1 N1.$42.li1 9.3
Rext_761 N1.$22.li1 N1.$24.li1 27.1058823529
Rext_762 N1.$22.li1 N1.P0.nsdm 185
Rext_763 N1.$220.met1 N1.$221.met1 0.195652173913
Rext_764 N1.$220.met1 N1.$44.li1 9.3
Rext_765 N1.$221.met1 N1.$222.met1 0.195652173913
Rext_766 N1.$221.met1 N1.$46.li1 9.3
Rext_767 N1.$222.met1 N1.$223.met1 0.195652173913
Rext_768 N1.$222.met1 N1.$48.li1 9.3
Rext_769 N1.$223.met1 N1.$224.met1 0.195652173913
Rext_770 N1.$223.met1 N1.$50.li1 9.3
Rext_771 N1.$224.met1 N1.$225.met1 0.195652173913
Rext_772 N1.$224.met1 N1.$52.li1 9.3
Rext_773 N1.$225.met1 N1.$226.met1 0.195652173913
Rext_774 N1.$225.met1 N1.$54.li1 9.3
Rext_775 N1.$226.met1 N1.$227.met1 0.195652173913
Rext_776 N1.$226.met1 N1.$56.li1 9.3
Rext_777 N1.$227.met1 N1.$228.met1 0.195652173913
Rext_778 N1.$227.met1 N1.$58.li1 9.3
Rext_779 N1.$228.met1 N1.$229.met1 0.195652173913
Rext_780 N1.$228.met1 N1.$60.li1 9.3
Rext_781 N1.$229.met1 N1.$230.met1 0.195652173913
Rext_782 N1.$229.met1 N1.$62.li1 9.3
Rext_783 N1.$230.met1 N1.$231.met1 0.195652173913
Rext_784 N1.$230.met1 N1.$64.li1 9.3
Rext_785 N1.$231.met1 N1.$232.met1 0.195652173913
Rext_786 N1.$231.met1 N1.$66.li1 9.3
Rext_787 N1.$232.met1 N1.$233.met1 0.195652173913
Rext_788 N1.$232.met1 N1.$68.li1 9.3
Rext_789 N1.$233.met1 N1.$234.met1 0.195652173913
Rext_790 N1.$233.met1 N1.$70.li1 9.3
Rext_791 N1.$234.met1 N1.$235.met1 0.195652173913
Rext_792 N1.$234.met1 N1.$72.li1 9.3
Rext_793 N1.$235.met1 N1.$236.met1 0.195652173913
Rext_794 N1.$235.met1 N1.$74.li1 9.3
Rext_795 N1.$236.met1 N1.$237.met1 0.195652173913
Rext_796 N1.$236.met1 N1.$76.li1 9.3
Rext_797 N1.$237.met1 N1.$238.met1 0.195652173913
Rext_798 N1.$237.met1 N1.$78.li1 9.3
Rext_799 N1.$238.met1 N1.$239.met1 0.195652173913
Rext_800 N1.$238.met1 N1.$80.li1 9.3
Rext_801 N1.$239.met1 N1.$240.met1 0.195652173913
Rext_802 N1.$239.met1 N1.$82.li1 9.3
Rext_803 N1.$24.li1 N1.$26.li1 27.1058823529
Rext_804 N1.$24.li1 N1.P0.nsdm 185
Rext_805 N1.$240.met1 N1.$241.met1 0.195652173913
Rext_806 N1.$240.met1 N1.$84.li1 9.3
Rext_807 N1.$241.met1 N1.$86.li1 9.3
Rext_808 N1.$242.met1 N1.$301.met2 4.5
Rext_809 N1.$243.met1 N1.$245.met1 0.195652173913
Rext_810 N1.$243.met1 N1.$88.li1 9.3
Rext_811 N1.$244.met1 N1.$246.met1 0.195652173913
Rext_812 N1.$244.met1 N1.$90.li1 9.3
Rext_813 N1.$245.met1 N1.$247.met1 0.195652173913
Rext_814 N1.$245.met1 N1.$92.li1 9.3
Rext_815 N1.$246.met1 N1.$248.met1 0.195652173913
Rext_816 N1.$246.met1 N1.$94.li1 9.3
Rext_817 N1.$247.met1 N1.$250.met1 0.195652173913
Rext_818 N1.$247.met1 N1.$96.li1 9.3
Rext_819 N1.$248.met1 N1.$249.met1 0.0461956521739
Rext_820 N1.$248.met1 N1.$98.li1 9.3
Rext_821 N1.$249.met1 N1.$251.met1 0.149456521739
Rext_822 N1.$249.met1 N1.$303.met2 4.5
Rext_823 N1.$250.met1 N1.$252.met1 0.195652173913
Rext_824 N1.$251.met1 N1.$253.met1 0.195652173913
Rext_825 N1.$252.met1 N1.$254.met1 0.195652173913
Rext_826 N1.$253.met1 N1.$255.met1 0.195652173913
Rext_827 N1.$254.met1 N1.$256.met1 0.195652173913
Rext_828 N1.$255.met1 N1.$257.met1 0.195652173913
Rext_829 N1.$256.met1 N1.$258.met1 0.195652173913
Rext_830 N1.$257.met1 N1.$259.met1 0.195652173913
Rext_831 N1.$258.met1 N1.$260.met1 0.195652173913
Rext_832 N1.$259.met1 N1.$261.met1 0.195652173913
Rext_833 N1.$26.li1 N1.$28.li1 27.1058823529
Rext_834 N1.$26.li1 N1.P0.nsdm 185
Rext_835 N1.$260.met1 N1.$262.met1 0.195652173913
Rext_836 N1.$261.met1 N1.$263.met1 0.195652173913
Rext_837 N1.$262.met1 N1.$264.met1 0.195652173913
Rext_838 N1.$263.met1 N1.$265.met1 0.195652173913
Rext_839 N1.$266.met1 N1.$267.met1 0.0570652173913
Rext_840 N1.$266.met1 N1.$268.met1 0.138586956522
Rext_841 N1.$266.met1 N1.$306.met2 4.5
Rext_842 N1.$268.met1 N1.$269.met1 0.195652173913
Rext_843 N1.$269.met1 N1.$270.met1 0.195652173913
Rext_844 N1.$270.met1 N1.$271.met1 0.195652173913
Rext_845 N1.$271.met1 N1.$272.met1 0.195652173913
Rext_846 N1.$272.met1 N1.$273.met1 0.195652173913
Rext_847 N1.$273.met1 N1.$274.met1 0.195652173913
Rext_848 N1.$274.met1 N1.$275.met1 0.195652173913
Rext_849 N1.$275.met1 N1.$276.met1 0.195652173913
Rext_850 N1.$276.met1 N1.$277.met1 0.195652173913
Rext_851 N1.$278.met1 N1.$281.met1 0.195652173913
Rext_852 N1.$279.met1 N1.$280.met1 0.111413043478
Rext_853 N1.$28.li1 N1.$30.li1 27.1058823529
Rext_854 N1.$28.li1 N1.P0.nsdm 185
Rext_855 N1.$280.met1 N1.$282.met1 0.0842391304348
Rext_856 N1.$280.met1 N1.$307.met2 4.5
Rext_857 N1.$281.met1 N1.$283.met1 0.195652173913
Rext_858 N1.$282.met1 N1.$284.met1 0.195652173913
Rext_859 N1.$283.met1 N1.$285.met1 0.195652173913
Rext_860 N1.$284.met1 N1.$286.met1 0.195652173913
Rext_861 N1.$285.met1 N1.$287.met1 0.195652173913
Rext_862 N1.$286.met1 N1.$288.met1 0.195652173913
Rext_863 N1.$287.met1 N1.$289.met1 0.195652173913
Rext_864 N1.$288.met1 N1.$290.met1 0.195652173913
Rext_865 N1.$289.met1 N1.$291.met1 0.195652173913
Rext_866 N1.$290.met1 N1.$292.met1 0.195652173913
Rext_867 N1.$291.met1 N1.$293.met1 0.195652173913
Rext_868 N1.$292.met1 N1.$294.met1 0.195652173913
Rext_869 N1.$293.met1 N1.$295.met1 0.195652173913
Rext_870 N1.$294.met1 N1.$296.met1 0.195652173913
Rext_871 N1.$295.met1 N1.$297.met1 0.195652173913
Rext_872 N1.$296.met1 N1.$298.met1 0.195652173913
Rext_873 N1.$297.met1 N1.$299.met1 0.195652173913
Rext_874 N1.$298.met1 N1.$300.met1 0.195652173913
Rext_875 N1.$30.li1 N1.$32.li1 27.1058823529
Rext_876 N1.$30.li1 N1.P0.nsdm 185
Rext_877 N1.$302.met2 N1.$308.met3 3.41
Rext_878 N1.$303.met2 N1.$304.met2 2.26583446074
Rext_879 N1.$304.met2 N1.$305.met2 6.1875
Rext_880 N1.$304.met2 N1.$306.met2 0.0124146508806
Rext_881 N1.$304.met2 N1.$307.met2 2.48814746018
Rext_882 N1.$305.met2 N1.$309.met3 3.41
Rext_883 N1.$308.met3 N1.$309.met3 3.1725
Rext_884 N1.$32.li1 N1.$34.li1 27.1058823529
Rext_885 N1.$32.li1 N1.P0.nsdm 185
Rext_886 N1.$34.li1 N1.$36.li1 27.1058823529
Rext_887 N1.$34.li1 N1.P0.nsdm 185
Rext_888 N1.$354.poly N1.$88.li1 152
Rext_889 N1.$354.poly N1.$92.li1 152
Rext_890 N1.$354.poly N1.$96.li1 152
Rext_891 N1.$354.poly N1.P0.poly 28.49825
Rext_892 N1.$355.poly N1.$90.li1 152
Rext_893 N1.$355.poly N1.$94.li1 152
Rext_894 N1.$355.poly N1.$98.li1 152
Rext_895 N1.$355.poly N1.P0.poly 28.49825
Rext_896 N1.$36.li1 N1.$38.li1 27.1058823529
Rext_897 N1.$36.li1 N1.P0.nsdm 185
Rext_898 N1.$376.poly N1.P1.poly 28.49825
Rext_899 N1.$377.poly N1.P1.poly 28.49825
Rext_900 N1.$38.li1 N1.$40.li1 27.1058823529
Rext_901 N1.$38.li1 N1.P0.nsdm 185
Rext_902 N1.$4.li1 N1.$6.li1 27.1058823529
Rext_903 N1.$4.li1 N1.P0.nsdm 185
Rext_904 N1.$40.li1 N1.$42.li1 27.1058823529
Rext_905 N1.$40.li1 N1.P0.nsdm 185
Rext_906 N1.$42.li1 N1.$44.li1 27.1058823529
Rext_907 N1.$42.li1 N1.P0.nsdm 185
Rext_908 N1.$44.li1 N1.$46.li1 27.1058823529
Rext_909 N1.$44.li1 N1.P0.nsdm 185
Rext_910 N1.$46.li1 N1.$48.li1 27.1058823529
Rext_911 N1.$46.li1 N1.P0.nsdm 185
Rext_912 N1.$48.li1 N1.$50.li1 27.1058823529
Rext_913 N1.$48.li1 N1.P0.nsdm 185
Rext_914 N1.$50.li1 N1.$52.li1 27.1058823529
Rext_915 N1.$50.li1 N1.P0.nsdm 185
Rext_916 N1.$52.li1 N1.$54.li1 27.1058823529
Rext_917 N1.$52.li1 N1.P0.nsdm 185
Rext_918 N1.$54.li1 N1.$56.li1 27.1058823529
Rext_919 N1.$54.li1 N1.P0.nsdm 185
Rext_920 N1.$56.li1 N1.$58.li1 27.1058823529
Rext_921 N1.$56.li1 N1.P0.nsdm 185
Rext_922 N1.$58.li1 N1.$60.li1 27.1058823529
Rext_923 N1.$58.li1 N1.P0.nsdm 185
Rext_924 N1.$6.li1 N1.$8.li1 27.1058823529
Rext_925 N1.$6.li1 N1.P0.nsdm 185
Rext_926 N1.$60.li1 N1.$62.li1 27.1058823529
Rext_927 N1.$60.li1 N1.P0.nsdm 185
Rext_928 N1.$62.li1 N1.$64.li1 27.1058823529
Rext_929 N1.$62.li1 N1.P0.nsdm 185
Rext_930 N1.$64.li1 N1.$66.li1 27.1058823529
Rext_931 N1.$64.li1 N1.P0.nsdm 185
Rext_932 N1.$66.li1 N1.$68.li1 27.1058823529
Rext_933 N1.$66.li1 N1.P0.nsdm 185
Rext_934 N1.$68.li1 N1.$70.li1 27.1058823529
Rext_935 N1.$68.li1 N1.P0.nsdm 185
Rext_936 N1.$70.li1 N1.$72.li1 27.1058823529
Rext_937 N1.$70.li1 N1.P0.nsdm 185
Rext_938 N1.$72.li1 N1.$74.li1 27.1058823529
Rext_939 N1.$72.li1 N1.P0.nsdm 185
Rext_940 N1.$74.li1 N1.$76.li1 27.1058823529
Rext_941 N1.$74.li1 N1.P0.nsdm 185
Rext_942 N1.$76.li1 N1.$78.li1 27.1058823529
Rext_943 N1.$76.li1 N1.P0.nsdm 185
Rext_944 N1.$78.li1 N1.$80.li1 27.1058823529
Rext_945 N1.$78.li1 N1.P0.nsdm 185
Rext_946 N1.$8.li1 N1.P0.nsdm 185
Rext_947 N1.$80.li1 N1.$82.li1 27.1058823529
Rext_948 N1.$80.li1 N1.P0.nsdm 185
Rext_949 N1.$82.li1 N1.$84.li1 27.1058823529
Rext_950 N1.$82.li1 N1.P0.nsdm 185
Rext_951 N1.$84.li1 N1.$86.li1 27.1058823529
Rext_952 N1.$84.li1 N1.P0.nsdm 185
Rext_953 N1.$86.li1 N1.P0.nsdm 185
Rext_954 N1.$88.li1 N1.$92.li1 27.1058823529
Rext_955 N1.$90.li1 N1.$94.li1 27.1058823529
Rext_956 N1.$92.li1 N1.$96.li1 27.1058823529
Rext_957 N1.$94.li1 N1.$98.li1 27.1058823529
Rext_958 NB NB.$274.met2 0.175551311739
Rext_959 NB.$0.li1 NB.$176.met1 9.3
Rext_960 NB.$0.li1 NB.$299.poly 152
Rext_961 NB.$0.li1 NB.$4.li1 27.1058823529
Rext_962 NB.$10.li1 NB.$14.li1 27.1058823529
Rext_963 NB.$10.li1 NB.$181.met1 9.3
Rext_964 NB.$10.li1 NB.$300.poly 152
Rext_965 NB.$10.li1 NB.$6.li1 27.1058823529
Rext_966 NB.$100.li1 NB.$102.li1 27.1058823529
Rext_967 NB.$100.li1 NB.$229.met1 9.3
Rext_968 NB.$100.li1 NB.$98.li1 27.1058823529
Rext_969 NB.$100.li1 NB.P0.nsdm 185
Rext_970 NB.$102.li1 NB.$104.li1 27.1058823529
Rext_971 NB.$102.li1 NB.$230.met1 9.3
Rext_972 NB.$102.li1 NB.P0.nsdm 185
Rext_973 NB.$104.li1 NB.$106.li1 27.1058823529
Rext_974 NB.$104.li1 NB.$231.met1 9.3
Rext_975 NB.$104.li1 NB.P0.nsdm 185
Rext_976 NB.$106.li1 NB.$108.li1 27.1058823529
Rext_977 NB.$106.li1 NB.$232.met1 9.3
Rext_978 NB.$106.li1 NB.P0.nsdm 185
Rext_979 NB.$108.li1 NB.$110.li1 27.1058823529
Rext_980 NB.$108.li1 NB.$233.met1 9.3
Rext_981 NB.$108.li1 NB.P0.nsdm 185
Rext_982 NB.$110.li1 NB.$112.li1 27.1058823529
Rext_983 NB.$110.li1 NB.$234.met1 9.3
Rext_984 NB.$110.li1 NB.P0.nsdm 185
Rext_985 NB.$112.li1 NB.$114.li1 27.1058823529
Rext_986 NB.$112.li1 NB.$235.met1 9.3
Rext_987 NB.$112.li1 NB.P0.nsdm 185
Rext_988 NB.$114.li1 NB.$116.li1 27.1058823529
Rext_989 NB.$114.li1 NB.$236.met1 9.3
Rext_990 NB.$114.li1 NB.P0.nsdm 185
Rext_991 NB.$116.li1 NB.$118.li1 27.1058823529
Rext_992 NB.$116.li1 NB.$237.met1 9.3
Rext_993 NB.$116.li1 NB.P0.nsdm 185
Rext_994 NB.$118.li1 NB.$120.li1 27.1058823529
Rext_995 NB.$118.li1 NB.$238.met1 9.3
Rext_996 NB.$118.li1 NB.P0.nsdm 185
Rext_997 NB.$12.li1 NB.$16.li1 27.1058823529
Rext_998 NB.$12.li1 NB.$183.met1 9.3
Rext_999 NB.$12.li1 NB.$299.poly 152
Rext_1000 NB.$12.li1 NB.$8.li1 27.1058823529
Rext_1001 NB.$120.li1 NB.$122.li1 27.1058823529
Rext_1002 NB.$120.li1 NB.$239.met1 9.3
Rext_1003 NB.$120.li1 NB.P0.nsdm 185
Rext_1004 NB.$122.li1 NB.$124.li1 27.1058823529
Rext_1005 NB.$122.li1 NB.$240.met1 9.3
Rext_1006 NB.$122.li1 NB.P0.nsdm 185
Rext_1007 NB.$124.li1 NB.$126.li1 27.1058823529
Rext_1008 NB.$124.li1 NB.$241.met1 9.3
Rext_1009 NB.$124.li1 NB.P0.nsdm 185
Rext_1010 NB.$126.li1 NB.$128.li1 27.1058823529
Rext_1011 NB.$126.li1 NB.$242.met1 9.3
Rext_1012 NB.$126.li1 NB.P0.nsdm 185
Rext_1013 NB.$128.li1 NB.$130.li1 27.1058823529
Rext_1014 NB.$128.li1 NB.$243.met1 9.3
Rext_1015 NB.$128.li1 NB.P0.nsdm 185
Rext_1016 NB.$130.li1 NB.$244.met1 9.3
Rext_1017 NB.$130.li1 NB.P0.nsdm 185
Rext_1018 NB.$132.li1 NB.$134.li1 27.1058823529
Rext_1019 NB.$132.li1 NB.$245.met1 9.3
Rext_1020 NB.$132.li1 NB.P0.psdm 585
Rext_1021 NB.$134.li1 NB.$136.li1 27.1058823529
Rext_1022 NB.$134.li1 NB.$246.met1 9.3
Rext_1023 NB.$134.li1 NB.P0.psdm 585
Rext_1024 NB.$136.li1 NB.$138.li1 27.1058823529
Rext_1025 NB.$136.li1 NB.$247.met1 9.3
Rext_1026 NB.$136.li1 NB.P0.psdm 585
Rext_1027 NB.$138.li1 NB.$140.li1 27.1058823529
Rext_1028 NB.$138.li1 NB.$248.met1 9.3
Rext_1029 NB.$138.li1 NB.P0.psdm 585
Rext_1030 NB.$14.li1 NB.$18.li1 27.1058823529
Rext_1031 NB.$14.li1 NB.$184.met1 9.3
Rext_1032 NB.$14.li1 NB.$300.poly 152
Rext_1033 NB.$140.li1 NB.$142.li1 27.1058823529
Rext_1034 NB.$140.li1 NB.$249.met1 9.3
Rext_1035 NB.$140.li1 NB.P0.psdm 585
Rext_1036 NB.$142.li1 NB.$144.li1 27.1058823529
Rext_1037 NB.$142.li1 NB.$250.met1 9.3
Rext_1038 NB.$142.li1 NB.P0.psdm 585
Rext_1039 NB.$144.li1 NB.$146.li1 27.1058823529
Rext_1040 NB.$144.li1 NB.$251.met1 9.3
Rext_1041 NB.$144.li1 NB.P0.psdm 585
Rext_1042 NB.$146.li1 NB.$148.li1 27.1058823529
Rext_1043 NB.$146.li1 NB.$252.met1 9.3
Rext_1044 NB.$146.li1 NB.P0.psdm 585
Rext_1045 NB.$148.li1 NB.$150.li1 27.1058823529
Rext_1046 NB.$148.li1 NB.$253.met1 9.3
Rext_1047 NB.$148.li1 NB.P0.psdm 585
Rext_1048 NB.$150.li1 NB.$152.li1 27.1058823529
Rext_1049 NB.$150.li1 NB.$254.met1 9.3
Rext_1050 NB.$150.li1 NB.P0.psdm 585
Rext_1051 NB.$152.li1 NB.$154.li1 27.1058823529
Rext_1052 NB.$152.li1 NB.$255.met1 9.3
Rext_1053 NB.$152.li1 NB.P0.psdm 585
Rext_1054 NB.$154.li1 NB.$156.li1 27.1058823529
Rext_1055 NB.$154.li1 NB.$256.met1 9.3
Rext_1056 NB.$154.li1 NB.P0.psdm 585
Rext_1057 NB.$156.li1 NB.$158.li1 27.1058823529
Rext_1058 NB.$156.li1 NB.$257.met1 9.3
Rext_1059 NB.$156.li1 NB.P0.psdm 585
Rext_1060 NB.$158.li1 NB.$160.li1 27.1058823529
Rext_1061 NB.$158.li1 NB.$258.met1 9.3
Rext_1062 NB.$158.li1 NB.P0.psdm 585
Rext_1063 NB.$16.li1 NB.$185.met1 9.3
Rext_1064 NB.$16.li1 NB.$20.li1 27.1058823529
Rext_1065 NB.$16.li1 NB.$299.poly 152
Rext_1066 NB.$160.li1 NB.$162.li1 27.1058823529
Rext_1067 NB.$160.li1 NB.$259.met1 9.3
Rext_1068 NB.$160.li1 NB.P0.psdm 585
Rext_1069 NB.$162.li1 NB.$164.li1 27.1058823529
Rext_1070 NB.$162.li1 NB.$260.met1 9.3
Rext_1071 NB.$162.li1 NB.P0.psdm 585
Rext_1072 NB.$164.li1 NB.$166.li1 27.1058823529
Rext_1073 NB.$164.li1 NB.$261.met1 9.3
Rext_1074 NB.$164.li1 NB.P0.psdm 585
Rext_1075 NB.$166.li1 NB.$168.li1 27.1058823529
Rext_1076 NB.$166.li1 NB.$262.met1 9.3
Rext_1077 NB.$166.li1 NB.P0.psdm 585
Rext_1078 NB.$168.li1 NB.$170.li1 27.1058823529
Rext_1079 NB.$168.li1 NB.$263.met1 9.3
Rext_1080 NB.$168.li1 NB.P0.psdm 585
Rext_1081 NB.$170.li1 NB.$172.li1 27.1058823529
Rext_1082 NB.$170.li1 NB.$264.met1 9.3
Rext_1083 NB.$170.li1 NB.P0.psdm 585
Rext_1084 NB.$172.li1 NB.$174.li1 27.1058823529
Rext_1085 NB.$172.li1 NB.$265.met1 9.3
Rext_1086 NB.$172.li1 NB.P0.psdm 585
Rext_1087 NB.$174.li1 NB.$266.met1 9.3
Rext_1088 NB.$174.li1 NB.P0.psdm 585
Rext_1089 NB.$176.met1 NB.$178.met1 0.195652173913
Rext_1090 NB.$177.met1 NB.$179.met1 0.195652173913
Rext_1091 NB.$177.met1 NB.$2.li1 9.3
Rext_1092 NB.$178.met1 NB.$180.met1 0.195652173913
Rext_1093 NB.$178.met1 NB.$4.li1 9.3
Rext_1094 NB.$179.met1 NB.$181.met1 0.195652173913
Rext_1095 NB.$179.met1 NB.$6.li1 9.3
Rext_1096 NB.$18.li1 NB.$186.met1 9.3
Rext_1097 NB.$18.li1 NB.$22.li1 27.1058823529
Rext_1098 NB.$18.li1 NB.$300.poly 152
Rext_1099 NB.$180.met1 NB.$182.met1 0.0190217391304
Rext_1100 NB.$180.met1 NB.$8.li1 9.3
Rext_1101 NB.$181.met1 NB.$184.met1 0.195652173913
Rext_1102 NB.$182.met1 NB.$183.met1 0.176630434783
Rext_1103 NB.$182.met1 NB.$269.met2 4.5
Rext_1104 NB.$183.met1 NB.$185.met1 0.195652173913
Rext_1105 NB.$184.met1 NB.$186.met1 0.195652173913
Rext_1106 NB.$185.met1 NB.$187.met1 0.195652173913
Rext_1107 NB.$186.met1 NB.$188.met1 0.195652173913
Rext_1108 NB.$187.met1 NB.$189.met1 0.195652173913
Rext_1109 NB.$187.met1 NB.$20.li1 9.3
Rext_1110 NB.$188.met1 NB.$190.met1 0.195652173913
Rext_1111 NB.$188.met1 NB.$22.li1 9.3
Rext_1112 NB.$189.met1 NB.$191.met1 0.195652173913
Rext_1113 NB.$189.met1 NB.$24.li1 9.3
Rext_1114 NB.$190.met1 NB.$192.met1 0.195652173913
Rext_1115 NB.$190.met1 NB.$26.li1 9.3
Rext_1116 NB.$191.met1 NB.$193.met1 0.195652173913
Rext_1117 NB.$191.met1 NB.$28.li1 9.3
Rext_1118 NB.$192.met1 NB.$194.met1 0.195652173913
Rext_1119 NB.$192.met1 NB.$30.li1 9.3
Rext_1120 NB.$193.met1 NB.$195.met1 0.195652173913
Rext_1121 NB.$193.met1 NB.$32.li1 9.3
Rext_1122 NB.$194.met1 NB.$196.met1 0.195652173913
Rext_1123 NB.$194.met1 NB.$34.li1 9.3
Rext_1124 NB.$195.met1 NB.$197.met1 0.195652173913
Rext_1125 NB.$195.met1 NB.$36.li1 9.3
Rext_1126 NB.$196.met1 NB.$198.met1 0.195652173913
Rext_1127 NB.$196.met1 NB.$38.li1 9.3
Rext_1128 NB.$197.met1 NB.$40.li1 9.3
Rext_1129 NB.$198.met1 NB.$42.li1 9.3
Rext_1130 NB.$199.met1 NB.$201.met1 0.195652173913
Rext_1131 NB.$199.met1 NB.$44.li1 9.3
Rext_1132 NB.$2.li1 NB.$300.poly 152
Rext_1133 NB.$2.li1 NB.$6.li1 27.1058823529
Rext_1134 NB.$20.li1 NB.$24.li1 27.1058823529
Rext_1135 NB.$20.li1 NB.$299.poly 152
Rext_1136 NB.$200.met1 NB.$202.met1 0.195652173913
Rext_1137 NB.$200.met1 NB.$46.li1 9.3
Rext_1138 NB.$201.met1 NB.$203.met1 0.0516304347826
Rext_1139 NB.$201.met1 NB.$48.li1 9.3
Rext_1140 NB.$202.met1 NB.$205.met1 0.195652173913
Rext_1141 NB.$202.met1 NB.$50.li1 9.3
Rext_1142 NB.$203.met1 NB.$204.met1 0.14402173913
Rext_1143 NB.$203.met1 NB.$271.met2 4.5
Rext_1144 NB.$204.met1 NB.$206.met1 0.195652173913
Rext_1145 NB.$204.met1 NB.$52.li1 9.3
Rext_1146 NB.$205.met1 NB.$207.met1 0.195652173913
Rext_1147 NB.$205.met1 NB.$54.li1 9.3
Rext_1148 NB.$206.met1 NB.$208.met1 0.195652173913
Rext_1149 NB.$206.met1 NB.$56.li1 9.3
Rext_1150 NB.$207.met1 NB.$209.met1 0.195652173913
Rext_1151 NB.$207.met1 NB.$58.li1 9.3
Rext_1152 NB.$208.met1 NB.$210.met1 0.195652173913
Rext_1153 NB.$208.met1 NB.$60.li1 9.3
Rext_1154 NB.$209.met1 NB.$211.met1 0.195652173913
Rext_1155 NB.$209.met1 NB.$62.li1 9.3
Rext_1156 NB.$210.met1 NB.$212.met1 0.195652173913
Rext_1157 NB.$210.met1 NB.$64.li1 9.3
Rext_1158 NB.$211.met1 NB.$213.met1 0.195652173913
Rext_1159 NB.$211.met1 NB.$66.li1 9.3
Rext_1160 NB.$212.met1 NB.$214.met1 0.195652173913
Rext_1161 NB.$212.met1 NB.$68.li1 9.3
Rext_1162 NB.$213.met1 NB.$215.met1 0.195652173913
Rext_1163 NB.$213.met1 NB.$70.li1 9.3
Rext_1164 NB.$214.met1 NB.$216.met1 0.195652173913
Rext_1165 NB.$214.met1 NB.$72.li1 9.3
Rext_1166 NB.$215.met1 NB.$217.met1 0.195652173913
Rext_1167 NB.$215.met1 NB.$74.li1 9.3
Rext_1168 NB.$216.met1 NB.$218.met1 0.195652173913
Rext_1169 NB.$216.met1 NB.$76.li1 9.3
Rext_1170 NB.$217.met1 NB.$219.met1 0.195652173913
Rext_1171 NB.$217.met1 NB.$78.li1 9.3
Rext_1172 NB.$218.met1 NB.$220.met1 0.195652173913
Rext_1173 NB.$218.met1 NB.$80.li1 9.3
Rext_1174 NB.$219.met1 NB.$221.met1 0.195652173913
Rext_1175 NB.$219.met1 NB.$82.li1 9.3
Rext_1176 NB.$22.li1 NB.$26.li1 27.1058823529
Rext_1177 NB.$22.li1 NB.$300.poly 152
Rext_1178 NB.$220.met1 NB.$84.li1 9.3
Rext_1179 NB.$221.met1 NB.$86.li1 9.3
Rext_1180 NB.$222.met1 NB.$223.met1 0.192934782609
Rext_1181 NB.$222.met1 NB.$224.met1 0.00271739130435
Rext_1182 NB.$222.met1 NB.$273.met2 4.5
Rext_1183 NB.$223.met1 NB.$88.li1 9.3
Rext_1184 NB.$224.met1 NB.$225.met1 0.195652173913
Rext_1185 NB.$224.met1 NB.$90.li1 9.3
Rext_1186 NB.$225.met1 NB.$226.met1 0.195652173913
Rext_1187 NB.$225.met1 NB.$92.li1 9.3
Rext_1188 NB.$226.met1 NB.$227.met1 0.195652173913
Rext_1189 NB.$226.met1 NB.$94.li1 9.3
Rext_1190 NB.$227.met1 NB.$228.met1 0.195652173913
Rext_1191 NB.$227.met1 NB.$96.li1 9.3
Rext_1192 NB.$228.met1 NB.$229.met1 0.195652173913
Rext_1193 NB.$228.met1 NB.$98.li1 9.3
Rext_1194 NB.$229.met1 NB.$230.met1 0.195652173913
Rext_1195 NB.$230.met1 NB.$231.met1 0.195652173913
Rext_1196 NB.$231.met1 NB.$232.met1 0.195652173913
Rext_1197 NB.$232.met1 NB.$233.met1 0.195652173913
Rext_1198 NB.$233.met1 NB.$234.met1 0.195652173913
Rext_1199 NB.$234.met1 NB.$235.met1 0.195652173913
Rext_1200 NB.$235.met1 NB.$236.met1 0.195652173913
Rext_1201 NB.$236.met1 NB.$237.met1 0.195652173913
Rext_1202 NB.$237.met1 NB.$238.met1 0.195652173913
Rext_1203 NB.$238.met1 NB.$239.met1 0.195652173913
Rext_1204 NB.$239.met1 NB.$240.met1 0.195652173913
Rext_1205 NB.$24.li1 NB.$28.li1 27.1058823529
Rext_1206 NB.$24.li1 NB.$299.poly 152
Rext_1207 NB.$240.met1 NB.$241.met1 0.195652173913
Rext_1208 NB.$241.met1 NB.$242.met1 0.195652173913
Rext_1209 NB.$242.met1 NB.$243.met1 0.195652173913
Rext_1210 NB.$243.met1 NB.$244.met1 0.195652173913
Rext_1211 NB.$245.met1 NB.$267.met1 0.0298913043478
Rext_1212 NB.$246.met1 NB.$247.met1 0.195652173913
Rext_1213 NB.$246.met1 NB.$267.met1 0.165760869565
Rext_1214 NB.$247.met1 NB.$248.met1 0.195652173913
Rext_1215 NB.$248.met1 NB.$249.met1 0.195652173913
Rext_1216 NB.$249.met1 NB.$250.met1 0.195652173913
Rext_1217 NB.$250.met1 NB.$251.met1 0.195652173913
Rext_1218 NB.$251.met1 NB.$252.met1 0.195652173913
Rext_1219 NB.$252.met1 NB.$253.met1 0.195652173913
Rext_1220 NB.$253.met1 NB.$254.met1 0.195652173913
Rext_1221 NB.$254.met1 NB.$255.met1 0.195652173913
Rext_1222 NB.$255.met1 NB.$256.met1 0.195652173913
Rext_1223 NB.$256.met1 NB.$257.met1 0.195652173913
Rext_1224 NB.$257.met1 NB.$258.met1 0.195652173913
Rext_1225 NB.$258.met1 NB.$259.met1 0.195652173913
Rext_1226 NB.$259.met1 NB.$260.met1 0.195652173913
Rext_1227 NB.$26.li1 NB.$30.li1 27.1058823529
Rext_1228 NB.$26.li1 NB.$300.poly 152
Rext_1229 NB.$260.met1 NB.$261.met1 0.195652173913
Rext_1230 NB.$261.met1 NB.$262.met1 0.195652173913
Rext_1231 NB.$262.met1 NB.$263.met1 0.195652173913
Rext_1232 NB.$263.met1 NB.$264.met1 0.195652173913
Rext_1233 NB.$264.met1 NB.$265.met1 0.195652173913
Rext_1234 NB.$265.met1 NB.$266.met1 0.195652173913
Rext_1235 NB.$267.met1 NB.$274.met2 4.5
Rext_1236 NB.$268.met2 NB.$269.met2 0.00609756097561
Rext_1237 NB.$268.met2 NB.$275.met3 3.41
Rext_1238 NB.$270.met2 NB.$271.met2 0.0116231926591
Rext_1239 NB.$270.met2 NB.$272.met2 1.42359373303
Rext_1240 NB.$270.met2 NB.$276.met3 3.41
Rext_1241 NB.$272.met2 NB.$273.met2 0.0867273787147
Rext_1242 NB.$272.met2 NB.$274.met2 7.21137536832
Rext_1243 NB.$275.met3 NB.$276.met3 0.74025
Rext_1244 NB.$28.li1 NB.$299.poly 152
Rext_1245 NB.$28.li1 NB.$32.li1 27.1058823529
Rext_1246 NB.$299.poly NB.$32.li1 152
Rext_1247 NB.$299.poly NB.$36.li1 152
Rext_1248 NB.$299.poly NB.$4.li1 152
Rext_1249 NB.$299.poly NB.$40.li1 152
Rext_1250 NB.$299.poly NB.$8.li1 152
Rext_1251 NB.$299.poly NB.P0.poly 52.59825
Rext_1252 NB.$30.li1 NB.$300.poly 152
Rext_1253 NB.$30.li1 NB.$34.li1 27.1058823529
Rext_1254 NB.$300.poly NB.$34.li1 152
Rext_1255 NB.$300.poly NB.$38.li1 152
Rext_1256 NB.$300.poly NB.$42.li1 152
Rext_1257 NB.$300.poly NB.$6.li1 152
Rext_1258 NB.$300.poly NB.P0.poly 52.59825
Rext_1259 NB.$32.li1 NB.$36.li1 27.1058823529
Rext_1260 NB.$321.poly NB.$44.li1 152
Rext_1261 NB.$321.poly NB.$48.li1 152
Rext_1262 NB.$321.poly NB.$52.li1 152
Rext_1263 NB.$321.poly NB.$56.li1 152
Rext_1264 NB.$321.poly NB.$60.li1 152
Rext_1265 NB.$321.poly NB.$64.li1 152
Rext_1266 NB.$321.poly NB.$68.li1 152
Rext_1267 NB.$321.poly NB.$72.li1 152
Rext_1268 NB.$321.poly NB.$76.li1 152
Rext_1269 NB.$321.poly NB.$80.li1 152
Rext_1270 NB.$321.poly NB.$84.li1 152
Rext_1271 NB.$321.poly NB.P1.poly 52.59825
Rext_1272 NB.$322.poly NB.$46.li1 152
Rext_1273 NB.$322.poly NB.$50.li1 152
Rext_1274 NB.$322.poly NB.$54.li1 152
Rext_1275 NB.$322.poly NB.$58.li1 152
Rext_1276 NB.$322.poly NB.$62.li1 152
Rext_1277 NB.$322.poly NB.$66.li1 152
Rext_1278 NB.$322.poly NB.$70.li1 152
Rext_1279 NB.$322.poly NB.$74.li1 152
Rext_1280 NB.$322.poly NB.$78.li1 152
Rext_1281 NB.$322.poly NB.$82.li1 152
Rext_1282 NB.$322.poly NB.$86.li1 152
Rext_1283 NB.$322.poly NB.P1.poly 52.59825
Rext_1284 NB.$34.li1 NB.$38.li1 27.1058823529
Rext_1285 NB.$36.li1 NB.$40.li1 27.1058823529
Rext_1286 NB.$38.li1 NB.$42.li1 27.1058823529
Rext_1287 NB.$4.li1 NB.$8.li1 27.1058823529
Rext_1288 NB.$44.li1 NB.$48.li1 27.1058823529
Rext_1289 NB.$46.li1 NB.$50.li1 27.1058823529
Rext_1290 NB.$48.li1 NB.$52.li1 27.1058823529
Rext_1291 NB.$50.li1 NB.$54.li1 27.1058823529
Rext_1292 NB.$52.li1 NB.$56.li1 27.1058823529
Rext_1293 NB.$54.li1 NB.$58.li1 27.1058823529
Rext_1294 NB.$56.li1 NB.$60.li1 27.1058823529
Rext_1295 NB.$58.li1 NB.$62.li1 27.1058823529
Rext_1296 NB.$60.li1 NB.$64.li1 27.1058823529
Rext_1297 NB.$62.li1 NB.$66.li1 27.1058823529
Rext_1298 NB.$64.li1 NB.$68.li1 27.1058823529
Rext_1299 NB.$66.li1 NB.$70.li1 27.1058823529
Rext_1300 NB.$68.li1 NB.$72.li1 27.1058823529
Rext_1301 NB.$70.li1 NB.$74.li1 27.1058823529
Rext_1302 NB.$72.li1 NB.$76.li1 27.1058823529
Rext_1303 NB.$74.li1 NB.$78.li1 27.1058823529
Rext_1304 NB.$76.li1 NB.$80.li1 27.1058823529
Rext_1305 NB.$78.li1 NB.$82.li1 27.1058823529
Rext_1306 NB.$80.li1 NB.$84.li1 27.1058823529
Rext_1307 NB.$82.li1 NB.$86.li1 27.1058823529
Rext_1308 NB.$88.li1 NB.$90.li1 27.1058823529
Rext_1309 NB.$88.li1 NB.P0.nsdm 185
Rext_1310 NB.$90.li1 NB.$92.li1 27.1058823529
Rext_1311 NB.$90.li1 NB.P0.nsdm 185
Rext_1312 NB.$92.li1 NB.$94.li1 27.1058823529
Rext_1313 NB.$92.li1 NB.P0.nsdm 185
Rext_1314 NB.$94.li1 NB.$96.li1 27.1058823529
Rext_1315 NB.$94.li1 NB.P0.nsdm 185
Rext_1316 NB.$96.li1 NB.$98.li1 27.1058823529
Rext_1317 NB.$96.li1 NB.P0.nsdm 185
Rext_1318 NB.$98.li1 NB.P0.nsdm 185
Rext_1319 net1 net1.$598.met2 0.0211360466338
Rext_1320 net1 net1.$600.met2 2.51415475808
Rext_1321 net1 net1.$616.met3 3.41
Rext_1322 net1.$288.li1 net1.$291.li1 6.76571428571
Rext_1323 net1.$288.li1 net1.$292.li1 6.4
Rext_1324 net1.$288.li1 net1.$623.poly 11.56
Rext_1325 net1.$289.li1 net1.$290.li1 13.1657142857
Rext_1326 net1.$289.li1 net1.$591.met1 9.3
Rext_1327 net1.$290.li1 net1.$291.li1 13.1657142857
Rext_1328 net1.$290.li1 net1.$592.met1 9.3
Rext_1329 net1.$291.li1 net1.$594.met1 9.3
Rext_1330 net1.$292.li1 net1.$293.li1 13.1657142857
Rext_1331 net1.$292.li1 net1.$595.met1 9.3
Rext_1332 net1.$293.li1 net1.$294.li1 13.1657142857
Rext_1333 net1.$293.li1 net1.$596.met1 9.3
Rext_1334 net1.$294.li1 net1.$597.met1 9.3
Rext_1335 net1.$295.met1 net1.$298.met1 0.00734889408025
Rext_1336 net1.$295.met1 net1.$598.met2 4.5
Rext_1337 net1.$296.met1 net1.$304.met1 0.00734889408025
Rext_1338 net1.$296.met1 net1.$600.met2 4.5
Rext_1339 net1.$297.met1 net1.$310.met1 0.00734889408025
Rext_1340 net1.$297.met1 net1.$601.met2 4.5
Rext_1341 net1.$298.met1 net1.$316.met1 0.0205252370824
Rext_1342 net1.$298.met1 net1.P0.li1 1.55
Rext_1343 net1.$304.met1 net1.$322.met1 0.0205252370824
Rext_1344 net1.$304.met1 net1.P435.li1 1.55
Rext_1345 net1.$310.met1 net1.$328.met1 0.0205252370824
Rext_1346 net1.$310.met1 net1.P261.li1 1.55
Rext_1347 net1.$316.met1 net1.$334.met1 0.0204918032787
Rext_1348 net1.$316.met1 net1.P0.li1 1.55
Rext_1349 net1.$322.met1 net1.$340.met1 0.0204918032787
Rext_1350 net1.$322.met1 net1.P435.li1 1.55
Rext_1351 net1.$328.met1 net1.$346.met1 0.0204918032787
Rext_1352 net1.$328.met1 net1.P261.li1 1.55
Rext_1353 net1.$334.met1 net1.$352.met1 0.0204918032787
Rext_1354 net1.$334.met1 net1.P0.li1 1.55
Rext_1355 net1.$340.met1 net1.$358.met1 0.0204918032787
Rext_1356 net1.$340.met1 net1.P435.li1 1.55
Rext_1357 net1.$346.met1 net1.$364.met1 0.0204918032787
Rext_1358 net1.$346.met1 net1.P261.li1 1.55
Rext_1359 net1.$352.met1 net1.$370.met1 0.0204918032787
Rext_1360 net1.$352.met1 net1.P0.li1 1.55
Rext_1361 net1.$358.met1 net1.$376.met1 0.0204918032787
Rext_1362 net1.$358.met1 net1.P435.li1 1.55
Rext_1363 net1.$364.met1 net1.$382.met1 0.0204918032787
Rext_1364 net1.$364.met1 net1.P261.li1 1.55
Rext_1365 net1.$370.met1 net1.$388.met1 0.0204918032787
Rext_1366 net1.$370.met1 net1.P0.li1 1.55
Rext_1367 net1.$376.met1 net1.$394.met1 0.0204918032787
Rext_1368 net1.$376.met1 net1.P435.li1 1.55
Rext_1369 net1.$382.met1 net1.$400.met1 0.0204918032787
Rext_1370 net1.$382.met1 net1.P261.li1 1.55
Rext_1371 net1.$388.met1 net1.P0.li1 1.55
Rext_1372 net1.$394.met1 net1.P435.li1 1.55
Rext_1373 net1.$400.met1 net1.P261.li1 1.55
Rext_1374 net1.$406.met1 net1.$408.met1 0.00734889408025
Rext_1375 net1.$406.met1 net1.$602.met2 4.5
Rext_1376 net1.$407.met1 net1.$414.met1 0.00734889408025
Rext_1377 net1.$407.met1 net1.$605.met2 4.5
Rext_1378 net1.$408.met1 net1.$420.met1 0.0205252370824
Rext_1379 net1.$408.met1 net1.P609.li1 1.55
Rext_1380 net1.$414.met1 net1.$426.met1 0.0205252370824
Rext_1381 net1.$414.met1 net1.P174.li1 1.55
Rext_1382 net1.$420.met1 net1.$432.met1 0.0204918032787
Rext_1383 net1.$420.met1 net1.P609.li1 1.55
Rext_1384 net1.$426.met1 net1.$438.met1 0.0204918032787
Rext_1385 net1.$426.met1 net1.P174.li1 1.55
Rext_1386 net1.$432.met1 net1.$444.met1 0.0204918032787
Rext_1387 net1.$432.met1 net1.P609.li1 1.55
Rext_1388 net1.$438.met1 net1.$450.met1 0.0204918032787
Rext_1389 net1.$438.met1 net1.P174.li1 1.55
Rext_1390 net1.$444.met1 net1.$456.met1 0.0204918032787
Rext_1391 net1.$444.met1 net1.P609.li1 1.55
Rext_1392 net1.$450.met1 net1.$462.met1 0.0204918032787
Rext_1393 net1.$450.met1 net1.P174.li1 1.55
Rext_1394 net1.$456.met1 net1.$468.met1 0.0204918032787
Rext_1395 net1.$456.met1 net1.P609.li1 1.55
Rext_1396 net1.$462.met1 net1.$474.met1 0.0204918032787
Rext_1397 net1.$462.met1 net1.P174.li1 1.55
Rext_1398 net1.$468.met1 net1.P609.li1 1.55
Rext_1399 net1.$474.met1 net1.P174.li1 1.55
Rext_1400 net1.$480.met1 net1.$483.met1 0.00734889408025
Rext_1401 net1.$480.met1 net1.$609.met2 4.5
Rext_1402 net1.$481.met1 net1.$489.met1 0.00734889408025
Rext_1403 net1.$481.met1 net1.$611.met2 4.5
Rext_1404 net1.$482.met1 net1.$495.met1 0.00734889408025
Rext_1405 net1.$482.met1 net1.$612.met2 4.5
Rext_1406 net1.$483.met1 net1.$501.met1 0.0205252370824
Rext_1407 net1.$483.met1 net1.P522.li1 1.55
Rext_1408 net1.$489.met1 net1.$507.met1 0.0205252370824
Rext_1409 net1.$489.met1 net1.P348.li1 1.55
Rext_1410 net1.$495.met1 net1.$513.met1 0.0205252370824
Rext_1411 net1.$495.met1 net1.P100.li1 1.55
Rext_1412 net1.$501.met1 net1.$519.met1 0.0204918032787
Rext_1413 net1.$501.met1 net1.P522.li1 1.55
Rext_1414 net1.$507.met1 net1.$525.met1 0.0204918032787
Rext_1415 net1.$507.met1 net1.P348.li1 1.55
Rext_1416 net1.$513.met1 net1.$531.met1 0.0204918032787
Rext_1417 net1.$513.met1 net1.P100.li1 1.55
Rext_1418 net1.$519.met1 net1.$537.met1 0.0204918032787
Rext_1419 net1.$519.met1 net1.P522.li1 1.55
Rext_1420 net1.$525.met1 net1.$543.met1 0.0204918032787
Rext_1421 net1.$525.met1 net1.P348.li1 1.55
Rext_1422 net1.$531.met1 net1.$549.met1 0.0204918032787
Rext_1423 net1.$531.met1 net1.P100.li1 1.55
Rext_1424 net1.$537.met1 net1.$555.met1 0.0204918032787
Rext_1425 net1.$537.met1 net1.P522.li1 1.55
Rext_1426 net1.$543.met1 net1.$561.met1 0.0204918032787
Rext_1427 net1.$543.met1 net1.P348.li1 1.55
Rext_1428 net1.$549.met1 net1.$567.met1 0.0204918032787
Rext_1429 net1.$549.met1 net1.P100.li1 1.55
Rext_1430 net1.$555.met1 net1.$573.met1 0.0204918032787
Rext_1431 net1.$555.met1 net1.P522.li1 1.55
Rext_1432 net1.$561.met1 net1.$579.met1 0.0204918032787
Rext_1433 net1.$561.met1 net1.P348.li1 1.55
Rext_1434 net1.$567.met1 net1.$585.met1 0.0204918032787
Rext_1435 net1.$567.met1 net1.P100.li1 1.55
Rext_1436 net1.$573.met1 net1.P522.li1 1.55
Rext_1437 net1.$579.met1 net1.P348.li1 1.55
Rext_1438 net1.$585.met1 net1.P100.li1 1.55
Rext_1439 net1.$591.met1 net1.$592.met1 0.18
Rext_1440 net1.$592.met1 net1.$593.met1 0.1025
Rext_1441 net1.$593.met1 net1.$594.met1 0.046875
Rext_1442 net1.$593.met1 net1.$615.met2 4.5
Rext_1443 net1.$594.met1 net1.$595.met1 0.175625
Rext_1444 net1.$595.met1 net1.$596.met1 0.18
Rext_1445 net1.$596.met1 net1.$597.met1 0.18
Rext_1446 net1.$600.met2 net1.$601.met2 2.54372830587
Rext_1447 net1.$602.met2 net1.$603.met2 0.00735294117647
Rext_1448 net1.$603.met2 net1.$617.met3 3.41
Rext_1449 net1.$604.met2 net1.$605.met2 2.22341580587
Rext_1450 net1.$604.met2 net1.$618.met3 3.41
Rext_1451 net1.$606.met2 net1.$607.met2 0.3125
Rext_1452 net1.$606.met2 net1.$619.met3 3.41
Rext_1453 net1.$607.met2 net1.$608.met2 2.88222077213
Rext_1454 net1.$607.met2 net1.$611.met2 0.257737698485
Rext_1455 net1.$608.met2 net1.$609.met2 0.00685451759969
Rext_1456 net1.$608.met2 net1.$610.met2 0.00704704945958
Rext_1457 net1.$610.met2 net1.$620.met3 3.41
Rext_1458 net1.$611.met2 net1.$612.met2 2.53529080471
Rext_1459 net1.$612.met2 net1.$613.met2 4.6953125
Rext_1460 net1.$613.met2 net1.$621.met3 3.41
Rext_1461 net1.$614.met2 net1.$615.met2 0.660129075385
Rext_1462 net1.$614.met2 net1.$622.met3 3.41
Rext_1463 net1.$616.met3 net1.$617.met3 0.846
Rext_1464 net1.$617.met3 net1.$620.met3 0.846
Rext_1465 net1.$618.met3 net1.$619.met3 0.74025
Rext_1466 net1.$621.met3 net1.$622.met3 8.2485
Rext_1467 net1.$623.poly net1.P0.poly 4.13142857143
Rext_1468 net2 net2.$87.met2 0.0211360466338
Rext_1469 net2 net2.$88.met2 6.89696725808
Rext_1470 net2.$36.li1 net2.$39.li1 6.76571428571
Rext_1471 net2.$36.li1 net2.$40.li1 6.4
Rext_1472 net2.$36.li1 net2.$93.poly 11.56
Rext_1473 net2.$37.li1 net2.$38.li1 13.1657142857
Rext_1474 net2.$37.li1 net2.$80.met1 9.3
Rext_1475 net2.$38.li1 net2.$39.li1 13.1657142857
Rext_1476 net2.$38.li1 net2.$82.met1 9.3
Rext_1477 net2.$39.li1 net2.$83.met1 9.3
Rext_1478 net2.$40.li1 net2.$41.li1 13.1657142857
Rext_1479 net2.$40.li1 net2.$84.met1 9.3
Rext_1480 net2.$41.li1 net2.$42.li1 13.1657142857
Rext_1481 net2.$41.li1 net2.$85.met1 9.3
Rext_1482 net2.$42.li1 net2.$86.met1 9.3
Rext_1483 net2.$43.met1 net2.$44.met1 0.00734889408025
Rext_1484 net2.$43.met1 net2.$87.met2 4.5
Rext_1485 net2.$44.met1 net2.$50.met1 0.0205252370824
Rext_1486 net2.$44.met1 net2.P0.li1 1.55
Rext_1487 net2.$50.met1 net2.$56.met1 0.0204918032787
Rext_1488 net2.$50.met1 net2.P0.li1 1.55
Rext_1489 net2.$56.met1 net2.$62.met1 0.0204918032787
Rext_1490 net2.$56.met1 net2.P0.li1 1.55
Rext_1491 net2.$62.met1 net2.$68.met1 0.0204918032787
Rext_1492 net2.$62.met1 net2.P0.li1 1.55
Rext_1493 net2.$68.met1 net2.$74.met1 0.0204918032787
Rext_1494 net2.$68.met1 net2.P0.li1 1.55
Rext_1495 net2.$74.met1 net2.P0.li1 1.55
Rext_1496 net2.$80.met1 net2.$81.met1 0.0625
Rext_1497 net2.$81.met1 net2.$82.met1 0.0625
Rext_1498 net2.$81.met1 net2.$90.met2 4.5
Rext_1499 net2.$82.met1 net2.$83.met1 0.18
Rext_1500 net2.$83.met1 net2.$84.met1 0.18
Rext_1501 net2.$84.met1 net2.$85.met1 0.18
Rext_1502 net2.$85.met1 net2.$86.met1 0.18
Rext_1503 net2.$88.met2 net2.$91.met3 3.41
Rext_1504 net2.$89.met2 net2.$90.met2 0.972629075385
Rext_1505 net2.$89.met2 net2.$92.met3 3.41
Rext_1506 net2.$91.met3 net2.$92.met3 6.23925
Rext_1507 net2.$93.poly net2.P0.poly 4.13142857143
Rext_1508 PB PB.$6021.met4 0.00047619047619
Rext_1509 PB PB.$6095.met4 0.00015873015873
Rext_1510 PB.$0.capm PB.$100.capm 0.0773333333333
Rext_1511 PB.$0.capm PB.$5947.met4 0.0460810810811
Rext_1512 PB.$100.capm PB.$148.capm 0.0773333333333
Rext_1513 PB.$100.capm PB.$6021.met4 0.0460810810811
Rext_1514 PB.$1000.capm PB.$1036.capm 0.0773333333333
Rext_1515 PB.$1000.capm PB.$6909.met4 0.0460810810811
Rext_1516 PB.$1000.capm PB.$888.capm 0.0773333333333
Rext_1517 PB.$10000.met4 PB.$10017.met4 0.000634920634921
Rext_1518 PB.$10000.met4 PB.$3996.capm 0.0460810810811
Rext_1519 PB.$10000.met4 PB.$9869.met4 0.000634920634921
Rext_1520 PB.$10017.met4 PB.$10091.met4 0.000634920634921
Rext_1521 PB.$10017.met4 PB.$4070.capm 0.0460810810811
Rext_1522 PB.$10091.met4 PB.$10165.met4 0.000634920634921
Rext_1523 PB.$10091.met4 PB.$4144.capm 0.0460810810811
Rext_1524 PB.$10165.met4 PB.$10239.met4 0.000634920634921
Rext_1525 PB.$10165.met4 PB.$4218.capm 0.0460810810811
Rext_1526 PB.$10239.met4 PB.$10313.met4 0.000634920634921
Rext_1527 PB.$10239.met4 PB.$4292.capm 0.0460810810811
Rext_1528 PB.$10313.met4 PB.$10387.met4 0.000634920634921
Rext_1529 PB.$10313.met4 PB.$4366.capm 0.0460810810811
Rext_1530 PB.$1036.capm PB.$1110.capm 0.0773333333333
Rext_1531 PB.$1036.capm PB.$6983.met4 0.0460810810811
Rext_1532 PB.$10387.met4 PB.$10461.met4 0.000634920634921
Rext_1533 PB.$10387.met4 PB.$4440.capm 0.0460810810811
Rext_1534 PB.$10461.met4 PB.$10535.met4 0.000634920634921
Rext_1535 PB.$10461.met4 PB.$4514.capm 0.0460810810811
Rext_1536 PB.$10535.met4 PB.$10609.met4 0.000634920634921
Rext_1537 PB.$10535.met4 PB.$4588.capm 0.0460810810811
Rext_1538 PB.$10609.met4 PB.$10683.met4 0.000634920634921
Rext_1539 PB.$10609.met4 PB.$4662.capm 0.0460810810811
Rext_1540 PB.$10683.met4 PB.$10757.met4 0.000634920634921
Rext_1541 PB.$10683.met4 PB.$4736.capm 0.0460810810811
Rext_1542 PB.$10757.met4 PB.$10831.met4 0.000634920634921
Rext_1543 PB.$10757.met4 PB.$4810.capm 0.0460810810811
Rext_1544 PB.$10831.met4 PB.$10905.met4 0.000634920634921
Rext_1545 PB.$10831.met4 PB.$4884.capm 0.0460810810811
Rext_1546 PB.$10905.met4 PB.$10979.met4 0.000634920634921
Rext_1547 PB.$10905.met4 PB.$4958.capm 0.0460810810811
Rext_1548 PB.$10979.met4 PB.$11053.met4 0.000634920634921
Rext_1549 PB.$10979.met4 PB.$5032.capm 0.0460810810811
Rext_1550 PB.$11053.met4 PB.$11127.met4 0.000634920634921
Rext_1551 PB.$11053.met4 PB.$5106.capm 0.0460810810811
Rext_1552 PB.$1110.capm PB.$1184.capm 0.0773333333333
Rext_1553 PB.$1110.capm PB.$7057.met4 0.0460810810811
Rext_1554 PB.$11127.met4 PB.$11201.met4 0.000634920634921
Rext_1555 PB.$11127.met4 PB.$5180.capm 0.0460810810811
Rext_1556 PB.$11201.met4 PB.$11275.met4 0.000634920634921
Rext_1557 PB.$11201.met4 PB.$5254.capm 0.0460810810811
Rext_1558 PB.$11275.met4 PB.$11349.met4 0.000634920634921
Rext_1559 PB.$11275.met4 PB.$5328.capm 0.0460810810811
Rext_1560 PB.$11349.met4 PB.$5402.capm 0.0460810810811
Rext_1561 PB.$11468.poly PB.$5476.li1 152
Rext_1562 PB.$11468.poly PB.$5480.li1 152
Rext_1563 PB.$11468.poly PB.$5484.li1 152
Rext_1564 PB.$11468.poly PB.$5488.li1 152
Rext_1565 PB.$11468.poly PB.$5492.li1 152
Rext_1566 PB.$11468.poly PB.$5496.li1 152
Rext_1567 PB.$11468.poly PB.$5500.li1 152
Rext_1568 PB.$11468.poly PB.$5504.li1 152
Rext_1569 PB.$11468.poly PB.$5508.li1 152
Rext_1570 PB.$11468.poly PB.$5512.li1 152
Rext_1571 PB.$11468.poly PB.$5516.li1 152
Rext_1572 PB.$11468.poly PB.P0.poly 52.59825
Rext_1573 PB.$11469.poly PB.$5478.li1 152
Rext_1574 PB.$11469.poly PB.$5482.li1 152
Rext_1575 PB.$11469.poly PB.$5486.li1 152
Rext_1576 PB.$11469.poly PB.$5490.li1 152
Rext_1577 PB.$11469.poly PB.$5494.li1 152
Rext_1578 PB.$11469.poly PB.$5498.li1 152
Rext_1579 PB.$11469.poly PB.$5502.li1 152
Rext_1580 PB.$11469.poly PB.$5506.li1 152
Rext_1581 PB.$11469.poly PB.$5510.li1 152
Rext_1582 PB.$11469.poly PB.$5514.li1 152
Rext_1583 PB.$11469.poly PB.$5518.li1 152
Rext_1584 PB.$11469.poly PB.P0.poly 52.59825
Rext_1585 PB.$11490.poly PB.$5520.li1 152
Rext_1586 PB.$11490.poly PB.$5524.li1 152
Rext_1587 PB.$11490.poly PB.$5528.li1 152
Rext_1588 PB.$11490.poly PB.$5532.li1 152
Rext_1589 PB.$11490.poly PB.$5536.li1 152
Rext_1590 PB.$11490.poly PB.$5540.li1 152
Rext_1591 PB.$11490.poly PB.$5544.li1 152
Rext_1592 PB.$11490.poly PB.$5548.li1 152
Rext_1593 PB.$11490.poly PB.$5552.li1 152
Rext_1594 PB.$11490.poly PB.$5556.li1 152
Rext_1595 PB.$11490.poly PB.$5648.li1 152
Rext_1596 PB.$11490.poly PB.P3.poly 52.59825
Rext_1597 PB.$11491.poly PB.$5522.li1 152
Rext_1598 PB.$11491.poly PB.$5526.li1 152
Rext_1599 PB.$11491.poly PB.$5530.li1 152
Rext_1600 PB.$11491.poly PB.$5534.li1 152
Rext_1601 PB.$11491.poly PB.$5538.li1 152
Rext_1602 PB.$11491.poly PB.$5542.li1 152
Rext_1603 PB.$11491.poly PB.$5546.li1 152
Rext_1604 PB.$11491.poly PB.$5550.li1 152
Rext_1605 PB.$11491.poly PB.$5554.li1 152
Rext_1606 PB.$11491.poly PB.$5558.li1 152
Rext_1607 PB.$11491.poly PB.$5650.li1 152
Rext_1608 PB.$11491.poly PB.P3.poly 52.59825
Rext_1609 PB.$11512.poly PB.$5652.li1 152
Rext_1610 PB.$11512.poly PB.$5656.li1 152
Rext_1611 PB.$11512.poly PB.$5660.li1 152
Rext_1612 PB.$11512.poly PB.$5664.li1 152
Rext_1613 PB.$11512.poly PB.$5668.li1 152
Rext_1614 PB.$11512.poly PB.$5672.li1 152
Rext_1615 PB.$11512.poly PB.$5676.li1 152
Rext_1616 PB.$11512.poly PB.$5680.li1 152
Rext_1617 PB.$11512.poly PB.$5684.li1 152
Rext_1618 PB.$11512.poly PB.$5688.li1 152
Rext_1619 PB.$11512.poly PB.$5692.li1 152
Rext_1620 PB.$11512.poly PB.P2.poly 52.59825
Rext_1621 PB.$11513.poly PB.$5654.li1 152
Rext_1622 PB.$11513.poly PB.$5658.li1 152
Rext_1623 PB.$11513.poly PB.$5662.li1 152
Rext_1624 PB.$11513.poly PB.$5666.li1 152
Rext_1625 PB.$11513.poly PB.$5670.li1 152
Rext_1626 PB.$11513.poly PB.$5674.li1 152
Rext_1627 PB.$11513.poly PB.$5678.li1 152
Rext_1628 PB.$11513.poly PB.$5682.li1 152
Rext_1629 PB.$11513.poly PB.$5686.li1 152
Rext_1630 PB.$11513.poly PB.$5690.li1 152
Rext_1631 PB.$11513.poly PB.$5694.li1 152
Rext_1632 PB.$11513.poly PB.P2.poly 52.59825
Rext_1633 PB.$11534.poly PB.$5696.li1 152
Rext_1634 PB.$11534.poly PB.$5700.li1 152
Rext_1635 PB.$11534.poly PB.$5704.li1 152
Rext_1636 PB.$11534.poly PB.$5708.li1 152
Rext_1637 PB.$11534.poly PB.$5712.li1 152
Rext_1638 PB.$11534.poly PB.$5716.li1 152
Rext_1639 PB.$11534.poly PB.$5720.li1 152
Rext_1640 PB.$11534.poly PB.$5724.li1 152
Rext_1641 PB.$11534.poly PB.$5728.li1 152
Rext_1642 PB.$11534.poly PB.$5732.li1 152
Rext_1643 PB.$11534.poly PB.$5736.li1 152
Rext_1644 PB.$11534.poly PB.P1.poly 52.59825
Rext_1645 PB.$11535.poly PB.$5698.li1 152
Rext_1646 PB.$11535.poly PB.$5702.li1 152
Rext_1647 PB.$11535.poly PB.$5706.li1 152
Rext_1648 PB.$11535.poly PB.$5710.li1 152
Rext_1649 PB.$11535.poly PB.$5714.li1 152
Rext_1650 PB.$11535.poly PB.$5718.li1 152
Rext_1651 PB.$11535.poly PB.$5722.li1 152
Rext_1652 PB.$11535.poly PB.$5726.li1 152
Rext_1653 PB.$11535.poly PB.$5730.li1 152
Rext_1654 PB.$11535.poly PB.$5734.li1 152
Rext_1655 PB.$11535.poly PB.$5738.li1 152
Rext_1656 PB.$11535.poly PB.P1.poly 52.59825
Rext_1657 PB.$1184.capm PB.$1258.capm 0.0773333333333
Rext_1658 PB.$1184.capm PB.$7131.met4 0.0460810810811
Rext_1659 PB.$1258.capm PB.$1332.capm 0.0773333333333
Rext_1660 PB.$1258.capm PB.$7205.met4 0.0460810810811
Rext_1661 PB.$1332.capm PB.$1406.capm 0.0773333333333
Rext_1662 PB.$1332.capm PB.$7279.met4 0.0460810810811
Rext_1663 PB.$1406.capm PB.$1480.capm 0.0773333333333
Rext_1664 PB.$1406.capm PB.$7353.met4 0.0460810810811
Rext_1665 PB.$148.capm PB.$222.capm 0.0773333333333
Rext_1666 PB.$148.capm PB.$6095.met4 0.0460810810811
Rext_1667 PB.$1480.capm PB.$1554.capm 0.0773333333333
Rext_1668 PB.$1480.capm PB.$7427.met4 0.0460810810811
Rext_1669 PB.$1554.capm PB.$1628.capm 0.0773333333333
Rext_1670 PB.$1554.capm PB.$7501.met4 0.0460810810811
Rext_1671 PB.$1628.capm PB.$1702.capm 0.0773333333333
Rext_1672 PB.$1628.capm PB.$7575.met4 0.0460810810811
Rext_1673 PB.$1702.capm PB.$1776.capm 0.0773333333333
Rext_1674 PB.$1702.capm PB.$7649.met4 0.0460810810811
Rext_1675 PB.$1776.capm PB.$1850.capm 0.0773333333333
Rext_1676 PB.$1776.capm PB.$7723.met4 0.0460810810811
Rext_1677 PB.$1850.capm PB.$1924.capm 0.0773333333333
Rext_1678 PB.$1850.capm PB.$7797.met4 0.0460810810811
Rext_1679 PB.$1924.capm PB.$1998.capm 0.0773333333333
Rext_1680 PB.$1924.capm PB.$7871.met4 0.0460810810811
Rext_1681 PB.$1998.capm PB.$2072.capm 0.0773333333333
Rext_1682 PB.$1998.capm PB.$7945.met4 0.0460810810811
Rext_1683 PB.$2072.capm PB.$2146.capm 0.0773333333333
Rext_1684 PB.$2072.capm PB.$8019.met4 0.0460810810811
Rext_1685 PB.$2146.capm PB.$2220.capm 0.0773333333333
Rext_1686 PB.$2146.capm PB.$8093.met4 0.0460810810811
Rext_1687 PB.$222.capm PB.$296.capm 0.0773333333333
Rext_1688 PB.$222.capm PB.$6169.met4 0.0460810810811
Rext_1689 PB.$2220.capm PB.$2294.capm 0.0773333333333
Rext_1690 PB.$2220.capm PB.$8167.met4 0.0460810810811
Rext_1691 PB.$2294.capm PB.$2368.capm 0.0773333333333
Rext_1692 PB.$2294.capm PB.$8241.met4 0.0460810810811
Rext_1693 PB.$2368.capm PB.$2442.capm 0.0773333333333
Rext_1694 PB.$2368.capm PB.$8315.met4 0.0460810810811
Rext_1695 PB.$2442.capm PB.$2516.capm 0.0773333333333
Rext_1696 PB.$2442.capm PB.$8389.met4 0.0460810810811
Rext_1697 PB.$2516.capm PB.$2590.capm 0.0773333333333
Rext_1698 PB.$2516.capm PB.$8463.met4 0.0460810810811
Rext_1699 PB.$2590.capm PB.$2664.capm 0.0773333333333
Rext_1700 PB.$2590.capm PB.$8537.met4 0.0460810810811
Rext_1701 PB.$2664.capm PB.$8611.met4 0.0460810810811
Rext_1702 PB.$2664.capm PB.P0.capm 0.0386666666667
Rext_1703 PB.$2738.capm PB.$2812.capm 0.0773333333333
Rext_1704 PB.$2738.capm PB.$8685.met4 0.0460810810811
Rext_1705 PB.$2738.capm PB.P0.capm 0.0386666666667
Rext_1706 PB.$2812.capm PB.$2886.capm 0.0773333333333
Rext_1707 PB.$2812.capm PB.$8759.met4 0.0460810810811
Rext_1708 PB.$2886.capm PB.$2960.capm 0.0773333333333
Rext_1709 PB.$2886.capm PB.$8833.met4 0.0460810810811
Rext_1710 PB.$296.capm PB.$370.capm 0.0773333333333
Rext_1711 PB.$296.capm PB.$6243.met4 0.0460810810811
Rext_1712 PB.$2960.capm PB.$3034.capm 0.0773333333333
Rext_1713 PB.$2960.capm PB.$8907.met4 0.0460810810811
Rext_1714 PB.$3034.capm PB.$3108.capm 0.0773333333333
Rext_1715 PB.$3034.capm PB.$8981.met4 0.0460810810811
Rext_1716 PB.$3108.capm PB.$3182.capm 0.0773333333333
Rext_1717 PB.$3108.capm PB.$9055.met4 0.0460810810811
Rext_1718 PB.$3182.capm PB.$3256.capm 0.0773333333333
Rext_1719 PB.$3182.capm PB.$9129.met4 0.0460810810811
Rext_1720 PB.$3256.capm PB.$3330.capm 0.0773333333333
Rext_1721 PB.$3256.capm PB.$9203.met4 0.0460810810811
Rext_1722 PB.$3330.capm PB.$3404.capm 0.0773333333333
Rext_1723 PB.$3330.capm PB.$9277.met4 0.0460810810811
Rext_1724 PB.$3404.capm PB.$3478.capm 0.0773333333333
Rext_1725 PB.$3404.capm PB.$9351.met4 0.0460810810811
Rext_1726 PB.$3478.capm PB.$3552.capm 0.0773333333333
Rext_1727 PB.$3478.capm PB.$9425.met4 0.0460810810811
Rext_1728 PB.$3552.capm PB.$3626.capm 0.0773333333333
Rext_1729 PB.$3552.capm PB.$9499.met4 0.0460810810811
Rext_1730 PB.$3626.capm PB.$3700.capm 0.0773333333333
Rext_1731 PB.$3626.capm PB.$9573.met4 0.0460810810811
Rext_1732 PB.$370.capm PB.$444.capm 0.0773333333333
Rext_1733 PB.$370.capm PB.$6317.met4 0.0460810810811
Rext_1734 PB.$3700.capm PB.$3774.capm 0.0773333333333
Rext_1735 PB.$3700.capm PB.$9647.met4 0.0460810810811
Rext_1736 PB.$3774.capm PB.$3848.capm 0.0773333333333
Rext_1737 PB.$3774.capm PB.$9721.met4 0.0460810810811
Rext_1738 PB.$3848.capm PB.$3922.capm 0.0773333333333
Rext_1739 PB.$3848.capm PB.$9795.met4 0.0460810810811
Rext_1740 PB.$3922.capm PB.$3996.capm 0.0773333333333
Rext_1741 PB.$3922.capm PB.$9869.met4 0.0460810810811
Rext_1742 PB.$3996.capm PB.$4070.capm 0.0773333333333
Rext_1743 PB.$4070.capm PB.$4144.capm 0.0773333333333
Rext_1744 PB.$4144.capm PB.$4218.capm 0.0773333333333
Rext_1745 PB.$4218.capm PB.$4292.capm 0.0773333333333
Rext_1746 PB.$4292.capm PB.$4366.capm 0.0773333333333
Rext_1747 PB.$4366.capm PB.$4440.capm 0.0773333333333
Rext_1748 PB.$444.capm PB.$518.capm 0.0773333333333
Rext_1749 PB.$444.capm PB.$6391.met4 0.0460810810811
Rext_1750 PB.$4440.capm PB.$4514.capm 0.0773333333333
Rext_1751 PB.$4514.capm PB.$4588.capm 0.0773333333333
Rext_1752 PB.$4588.capm PB.$4662.capm 0.0773333333333
Rext_1753 PB.$4662.capm PB.$4736.capm 0.0773333333333
Rext_1754 PB.$4736.capm PB.$4810.capm 0.0773333333333
Rext_1755 PB.$4810.capm PB.$4884.capm 0.0773333333333
Rext_1756 PB.$4884.capm PB.$4958.capm 0.0773333333333
Rext_1757 PB.$4958.capm PB.$5032.capm 0.0773333333333
Rext_1758 PB.$5032.capm PB.$5106.capm 0.0773333333333
Rext_1759 PB.$5106.capm PB.$5180.capm 0.0773333333333
Rext_1760 PB.$518.capm PB.$592.capm 0.0773333333333
Rext_1761 PB.$518.capm PB.$6465.met4 0.0460810810811
Rext_1762 PB.$5180.capm PB.$5254.capm 0.0773333333333
Rext_1763 PB.$5254.capm PB.$5328.capm 0.0773333333333
Rext_1764 PB.$5328.capm PB.$5402.capm 0.0773333333333
Rext_1765 PB.$5476.li1 PB.$5480.li1 27.1058823529
Rext_1766 PB.$5476.li1 PB.$5764.met1 9.3
Rext_1767 PB.$5478.li1 PB.$5482.li1 27.1058823529
Rext_1768 PB.$5478.li1 PB.$5765.met1 9.3
Rext_1769 PB.$5480.li1 PB.$5484.li1 27.1058823529
Rext_1770 PB.$5480.li1 PB.$5766.met1 9.3
Rext_1771 PB.$5482.li1 PB.$5486.li1 27.1058823529
Rext_1772 PB.$5482.li1 PB.$5767.met1 9.3
Rext_1773 PB.$5484.li1 PB.$5488.li1 27.1058823529
Rext_1774 PB.$5484.li1 PB.$5768.met1 9.3
Rext_1775 PB.$5486.li1 PB.$5490.li1 27.1058823529
Rext_1776 PB.$5486.li1 PB.$5769.met1 9.3
Rext_1777 PB.$5488.li1 PB.$5492.li1 27.1058823529
Rext_1778 PB.$5488.li1 PB.$5770.met1 9.3
Rext_1779 PB.$5490.li1 PB.$5494.li1 27.1058823529
Rext_1780 PB.$5490.li1 PB.$5771.met1 9.3
Rext_1781 PB.$5492.li1 PB.$5496.li1 27.1058823529
Rext_1782 PB.$5492.li1 PB.$5772.met1 9.3
Rext_1783 PB.$5494.li1 PB.$5498.li1 27.1058823529
Rext_1784 PB.$5494.li1 PB.$5773.met1 9.3
Rext_1785 PB.$5496.li1 PB.$5500.li1 27.1058823529
Rext_1786 PB.$5496.li1 PB.$5774.met1 9.3
Rext_1787 PB.$5498.li1 PB.$5502.li1 27.1058823529
Rext_1788 PB.$5498.li1 PB.$5775.met1 9.3
Rext_1789 PB.$5500.li1 PB.$5504.li1 27.1058823529
Rext_1790 PB.$5500.li1 PB.$5776.met1 9.3
Rext_1791 PB.$5502.li1 PB.$5506.li1 27.1058823529
Rext_1792 PB.$5502.li1 PB.$5777.met1 9.3
Rext_1793 PB.$5504.li1 PB.$5508.li1 27.1058823529
Rext_1794 PB.$5504.li1 PB.$5778.met1 9.3
Rext_1795 PB.$5506.li1 PB.$5510.li1 27.1058823529
Rext_1796 PB.$5506.li1 PB.$5779.met1 9.3
Rext_1797 PB.$5508.li1 PB.$5512.li1 27.1058823529
Rext_1798 PB.$5508.li1 PB.$5780.met1 9.3
Rext_1799 PB.$5510.li1 PB.$5514.li1 27.1058823529
Rext_1800 PB.$5510.li1 PB.$5781.met1 9.3
Rext_1801 PB.$5512.li1 PB.$5516.li1 27.1058823529
Rext_1802 PB.$5512.li1 PB.$5783.met1 9.3
Rext_1803 PB.$5514.li1 PB.$5518.li1 27.1058823529
Rext_1804 PB.$5514.li1 PB.$5784.met1 9.3
Rext_1805 PB.$5516.li1 PB.$5785.met1 9.3
Rext_1806 PB.$5518.li1 PB.$5786.met1 9.3
Rext_1807 PB.$5520.li1 PB.$5524.li1 27.1058823529
Rext_1808 PB.$5520.li1 PB.$5787.met1 9.3
Rext_1809 PB.$5522.li1 PB.$5526.li1 27.1058823529
Rext_1810 PB.$5522.li1 PB.$5788.met1 9.3
Rext_1811 PB.$5524.li1 PB.$5528.li1 27.1058823529
Rext_1812 PB.$5524.li1 PB.$5789.met1 9.3
Rext_1813 PB.$5526.li1 PB.$5530.li1 27.1058823529
Rext_1814 PB.$5526.li1 PB.$5790.met1 9.3
Rext_1815 PB.$5528.li1 PB.$5532.li1 27.1058823529
Rext_1816 PB.$5528.li1 PB.$5792.met1 9.3
Rext_1817 PB.$5530.li1 PB.$5534.li1 27.1058823529
Rext_1818 PB.$5530.li1 PB.$5793.met1 9.3
Rext_1819 PB.$5532.li1 PB.$5536.li1 27.1058823529
Rext_1820 PB.$5532.li1 PB.$5794.met1 9.3
Rext_1821 PB.$5534.li1 PB.$5538.li1 27.1058823529
Rext_1822 PB.$5534.li1 PB.$5795.met1 9.3
Rext_1823 PB.$5536.li1 PB.$5540.li1 27.1058823529
Rext_1824 PB.$5536.li1 PB.$5796.met1 9.3
Rext_1825 PB.$5538.li1 PB.$5542.li1 27.1058823529
Rext_1826 PB.$5538.li1 PB.$5797.met1 9.3
Rext_1827 PB.$5540.li1 PB.$5544.li1 27.1058823529
Rext_1828 PB.$5540.li1 PB.$5798.met1 9.3
Rext_1829 PB.$5542.li1 PB.$5546.li1 27.1058823529
Rext_1830 PB.$5542.li1 PB.$5799.met1 9.3
Rext_1831 PB.$5544.li1 PB.$5548.li1 27.1058823529
Rext_1832 PB.$5544.li1 PB.$5800.met1 9.3
Rext_1833 PB.$5546.li1 PB.$5550.li1 27.1058823529
Rext_1834 PB.$5546.li1 PB.$5801.met1 9.3
Rext_1835 PB.$5548.li1 PB.$5552.li1 27.1058823529
Rext_1836 PB.$5548.li1 PB.$5802.met1 9.3
Rext_1837 PB.$5550.li1 PB.$5554.li1 27.1058823529
Rext_1838 PB.$5550.li1 PB.$5803.met1 9.3
Rext_1839 PB.$5552.li1 PB.$5556.li1 27.1058823529
Rext_1840 PB.$5552.li1 PB.$5804.met1 9.3
Rext_1841 PB.$5554.li1 PB.$5558.li1 27.1058823529
Rext_1842 PB.$5554.li1 PB.$5805.met1 9.3
Rext_1843 PB.$5556.li1 PB.$5648.li1 27.1058823529
Rext_1844 PB.$5556.li1 PB.$5806.met1 9.3
Rext_1845 PB.$5558.li1 PB.$5650.li1 27.1058823529
Rext_1846 PB.$5558.li1 PB.$5807.met1 9.3
Rext_1847 PB.$5560.li1 PB.$5562.li1 27.1058823529
Rext_1848 PB.$5560.li1 PB.$5808.met1 9.3
Rext_1849 PB.$5560.li1 PB.P1.nsdm 185
Rext_1850 PB.$5562.li1 PB.$5564.li1 27.1058823529
Rext_1851 PB.$5562.li1 PB.$5809.met1 9.3
Rext_1852 PB.$5562.li1 PB.P1.nsdm 185
Rext_1853 PB.$5564.li1 PB.$5566.li1 27.1058823529
Rext_1854 PB.$5564.li1 PB.$5810.met1 9.3
Rext_1855 PB.$5564.li1 PB.P1.nsdm 185
Rext_1856 PB.$5566.li1 PB.$5568.li1 27.1058823529
Rext_1857 PB.$5566.li1 PB.$5811.met1 9.3
Rext_1858 PB.$5566.li1 PB.P1.nsdm 185
Rext_1859 PB.$5568.li1 PB.$5570.li1 27.1058823529
Rext_1860 PB.$5568.li1 PB.$5812.met1 9.3
Rext_1861 PB.$5568.li1 PB.P1.nsdm 185
Rext_1862 PB.$5570.li1 PB.$5572.li1 27.1058823529
Rext_1863 PB.$5570.li1 PB.$5813.met1 9.3
Rext_1864 PB.$5570.li1 PB.P1.nsdm 185
Rext_1865 PB.$5572.li1 PB.$5574.li1 27.1058823529
Rext_1866 PB.$5572.li1 PB.$5814.met1 9.3
Rext_1867 PB.$5572.li1 PB.P1.nsdm 185
Rext_1868 PB.$5574.li1 PB.$5576.li1 27.1058823529
Rext_1869 PB.$5574.li1 PB.$5815.met1 9.3
Rext_1870 PB.$5574.li1 PB.P1.nsdm 185
Rext_1871 PB.$5576.li1 PB.$5578.li1 27.1058823529
Rext_1872 PB.$5576.li1 PB.$5816.met1 9.3
Rext_1873 PB.$5576.li1 PB.P1.nsdm 185
Rext_1874 PB.$5578.li1 PB.$5580.li1 27.1058823529
Rext_1875 PB.$5578.li1 PB.$5817.met1 9.3
Rext_1876 PB.$5578.li1 PB.P1.nsdm 185
Rext_1877 PB.$5580.li1 PB.$5582.li1 27.1058823529
Rext_1878 PB.$5580.li1 PB.$5818.met1 9.3
Rext_1879 PB.$5580.li1 PB.P1.nsdm 185
Rext_1880 PB.$5582.li1 PB.$5584.li1 27.1058823529
Rext_1881 PB.$5582.li1 PB.$5819.met1 9.3
Rext_1882 PB.$5582.li1 PB.P1.nsdm 185
Rext_1883 PB.$5584.li1 PB.$5586.li1 27.1058823529
Rext_1884 PB.$5584.li1 PB.$5820.met1 9.3
Rext_1885 PB.$5584.li1 PB.P1.nsdm 185
Rext_1886 PB.$5586.li1 PB.$5588.li1 27.1058823529
Rext_1887 PB.$5586.li1 PB.$5821.met1 9.3
Rext_1888 PB.$5586.li1 PB.P1.nsdm 185
Rext_1889 PB.$5588.li1 PB.$5590.li1 27.1058823529
Rext_1890 PB.$5588.li1 PB.$5822.met1 9.3
Rext_1891 PB.$5588.li1 PB.P1.nsdm 185
Rext_1892 PB.$5590.li1 PB.$5592.li1 27.1058823529
Rext_1893 PB.$5590.li1 PB.$5823.met1 9.3
Rext_1894 PB.$5590.li1 PB.P1.nsdm 185
Rext_1895 PB.$5592.li1 PB.$5594.li1 27.1058823529
Rext_1896 PB.$5592.li1 PB.$5824.met1 9.3
Rext_1897 PB.$5592.li1 PB.P1.nsdm 185
Rext_1898 PB.$5594.li1 PB.$5596.li1 27.1058823529
Rext_1899 PB.$5594.li1 PB.$5825.met1 9.3
Rext_1900 PB.$5594.li1 PB.P1.nsdm 185
Rext_1901 PB.$5596.li1 PB.$5598.li1 27.1058823529
Rext_1902 PB.$5596.li1 PB.$5826.met1 9.3
Rext_1903 PB.$5596.li1 PB.P1.nsdm 185
Rext_1904 PB.$5598.li1 PB.$5600.li1 27.1058823529
Rext_1905 PB.$5598.li1 PB.$5827.met1 9.3
Rext_1906 PB.$5598.li1 PB.P1.nsdm 185
Rext_1907 PB.$5600.li1 PB.$5602.li1 27.1058823529
Rext_1908 PB.$5600.li1 PB.$5828.met1 9.3
Rext_1909 PB.$5600.li1 PB.P1.nsdm 185
Rext_1910 PB.$5602.li1 PB.$5604.li1 27.1058823529
Rext_1911 PB.$5602.li1 PB.$5829.met1 9.3
Rext_1912 PB.$5602.li1 PB.P1.nsdm 185
Rext_1913 PB.$5604.li1 PB.$5606.li1 27.1058823529
Rext_1914 PB.$5604.li1 PB.$5830.met1 9.3
Rext_1915 PB.$5604.li1 PB.P1.nsdm 185
Rext_1916 PB.$5606.li1 PB.$5608.li1 27.1058823529
Rext_1917 PB.$5606.li1 PB.$5831.met1 9.3
Rext_1918 PB.$5606.li1 PB.P1.nsdm 185
Rext_1919 PB.$5608.li1 PB.$5610.li1 27.1058823529
Rext_1920 PB.$5608.li1 PB.$5832.met1 9.3
Rext_1921 PB.$5608.li1 PB.P1.nsdm 185
Rext_1922 PB.$5610.li1 PB.$5612.li1 27.1058823529
Rext_1923 PB.$5610.li1 PB.$5833.met1 9.3
Rext_1924 PB.$5610.li1 PB.P1.nsdm 185
Rext_1925 PB.$5612.li1 PB.$5614.li1 27.1058823529
Rext_1926 PB.$5612.li1 PB.$5834.met1 9.3
Rext_1927 PB.$5612.li1 PB.P1.nsdm 185
Rext_1928 PB.$5614.li1 PB.$5616.li1 27.1058823529
Rext_1929 PB.$5614.li1 PB.$5835.met1 9.3
Rext_1930 PB.$5614.li1 PB.P1.nsdm 185
Rext_1931 PB.$5616.li1 PB.$5618.li1 27.1058823529
Rext_1932 PB.$5616.li1 PB.$5836.met1 9.3
Rext_1933 PB.$5616.li1 PB.P1.nsdm 185
Rext_1934 PB.$5618.li1 PB.$5620.li1 27.1058823529
Rext_1935 PB.$5618.li1 PB.$5837.met1 9.3
Rext_1936 PB.$5618.li1 PB.P1.nsdm 185
Rext_1937 PB.$5620.li1 PB.$5622.li1 27.1058823529
Rext_1938 PB.$5620.li1 PB.$5838.met1 9.3
Rext_1939 PB.$5620.li1 PB.P1.nsdm 185
Rext_1940 PB.$5622.li1 PB.$5624.li1 27.1058823529
Rext_1941 PB.$5622.li1 PB.$5839.met1 9.3
Rext_1942 PB.$5622.li1 PB.P1.nsdm 185
Rext_1943 PB.$5624.li1 PB.$5626.li1 27.1058823529
Rext_1944 PB.$5624.li1 PB.$5840.met1 9.3
Rext_1945 PB.$5624.li1 PB.P1.nsdm 185
Rext_1946 PB.$5626.li1 PB.$5628.li1 27.1058823529
Rext_1947 PB.$5626.li1 PB.$5841.met1 9.3
Rext_1948 PB.$5626.li1 PB.P1.nsdm 185
Rext_1949 PB.$5628.li1 PB.$5630.li1 27.1058823529
Rext_1950 PB.$5628.li1 PB.$5842.met1 9.3
Rext_1951 PB.$5628.li1 PB.P1.nsdm 185
Rext_1952 PB.$5630.li1 PB.$5632.li1 27.1058823529
Rext_1953 PB.$5630.li1 PB.$5843.met1 9.3
Rext_1954 PB.$5630.li1 PB.P1.nsdm 185
Rext_1955 PB.$5632.li1 PB.$5634.li1 27.1058823529
Rext_1956 PB.$5632.li1 PB.$5844.met1 9.3
Rext_1957 PB.$5632.li1 PB.P1.nsdm 185
Rext_1958 PB.$5634.li1 PB.$5636.li1 27.1058823529
Rext_1959 PB.$5634.li1 PB.$5845.met1 9.3
Rext_1960 PB.$5634.li1 PB.P1.nsdm 185
Rext_1961 PB.$5636.li1 PB.$5638.li1 27.1058823529
Rext_1962 PB.$5636.li1 PB.$5846.met1 9.3
Rext_1963 PB.$5636.li1 PB.P1.nsdm 185
Rext_1964 PB.$5638.li1 PB.$5640.li1 27.1058823529
Rext_1965 PB.$5638.li1 PB.$5847.met1 9.3
Rext_1966 PB.$5638.li1 PB.P1.nsdm 185
Rext_1967 PB.$5640.li1 PB.$5642.li1 27.1058823529
Rext_1968 PB.$5640.li1 PB.$5848.met1 9.3
Rext_1969 PB.$5640.li1 PB.P1.nsdm 185
Rext_1970 PB.$5642.li1 PB.$5644.li1 27.1058823529
Rext_1971 PB.$5642.li1 PB.$5849.met1 9.3
Rext_1972 PB.$5642.li1 PB.P1.nsdm 185
Rext_1973 PB.$5644.li1 PB.$5646.li1 27.1058823529
Rext_1974 PB.$5644.li1 PB.$5850.met1 9.3
Rext_1975 PB.$5644.li1 PB.P1.nsdm 185
Rext_1976 PB.$5646.li1 PB.$5851.met1 9.3
Rext_1977 PB.$5646.li1 PB.P1.nsdm 185
Rext_1978 PB.$5648.li1 PB.$5853.met1 9.3
Rext_1979 PB.$5650.li1 PB.$5854.met1 9.3
Rext_1980 PB.$5652.li1 PB.$5656.li1 27.1058823529
Rext_1981 PB.$5652.li1 PB.$5856.met1 9.3
Rext_1982 PB.$5654.li1 PB.$5658.li1 27.1058823529
Rext_1983 PB.$5654.li1 PB.$5857.met1 9.3
Rext_1984 PB.$5656.li1 PB.$5660.li1 27.1058823529
Rext_1985 PB.$5656.li1 PB.$5859.met1 9.3
Rext_1986 PB.$5658.li1 PB.$5662.li1 27.1058823529
Rext_1987 PB.$5658.li1 PB.$5860.met1 9.3
Rext_1988 PB.$5660.li1 PB.$5664.li1 27.1058823529
Rext_1989 PB.$5660.li1 PB.$5861.met1 9.3
Rext_1990 PB.$5662.li1 PB.$5666.li1 27.1058823529
Rext_1991 PB.$5662.li1 PB.$5862.met1 9.3
Rext_1992 PB.$5664.li1 PB.$5668.li1 27.1058823529
Rext_1993 PB.$5664.li1 PB.$5863.met1 9.3
Rext_1994 PB.$5666.li1 PB.$5670.li1 27.1058823529
Rext_1995 PB.$5666.li1 PB.$5864.met1 9.3
Rext_1996 PB.$5668.li1 PB.$5672.li1 27.1058823529
Rext_1997 PB.$5668.li1 PB.$5865.met1 9.3
Rext_1998 PB.$5670.li1 PB.$5674.li1 27.1058823529
Rext_1999 PB.$5670.li1 PB.$5866.met1 9.3
Rext_2000 PB.$5672.li1 PB.$5676.li1 27.1058823529
Rext_2001 PB.$5672.li1 PB.$5867.met1 9.3
Rext_2002 PB.$5674.li1 PB.$5678.li1 27.1058823529
Rext_2003 PB.$5674.li1 PB.$5868.met1 9.3
Rext_2004 PB.$5676.li1 PB.$5680.li1 27.1058823529
Rext_2005 PB.$5676.li1 PB.$5869.met1 9.3
Rext_2006 PB.$5678.li1 PB.$5682.li1 27.1058823529
Rext_2007 PB.$5678.li1 PB.$5870.met1 9.3
Rext_2008 PB.$5680.li1 PB.$5684.li1 27.1058823529
Rext_2009 PB.$5680.li1 PB.$5871.met1 9.3
Rext_2010 PB.$5682.li1 PB.$5686.li1 27.1058823529
Rext_2011 PB.$5682.li1 PB.$5872.met1 9.3
Rext_2012 PB.$5684.li1 PB.$5688.li1 27.1058823529
Rext_2013 PB.$5684.li1 PB.$5873.met1 9.3
Rext_2014 PB.$5686.li1 PB.$5690.li1 27.1058823529
Rext_2015 PB.$5686.li1 PB.$5874.met1 9.3
Rext_2016 PB.$5688.li1 PB.$5692.li1 27.1058823529
Rext_2017 PB.$5688.li1 PB.$5875.met1 9.3
Rext_2018 PB.$5690.li1 PB.$5694.li1 27.1058823529
Rext_2019 PB.$5690.li1 PB.$5876.met1 9.3
Rext_2020 PB.$5692.li1 PB.$5877.met1 9.3
Rext_2021 PB.$5694.li1 PB.$5878.met1 9.3
Rext_2022 PB.$5696.li1 PB.$5700.li1 27.1058823529
Rext_2023 PB.$5696.li1 PB.$5879.met1 9.3
Rext_2024 PB.$5698.li1 PB.$5702.li1 27.1058823529
Rext_2025 PB.$5698.li1 PB.$5880.met1 9.3
Rext_2026 PB.$5700.li1 PB.$5704.li1 27.1058823529
Rext_2027 PB.$5700.li1 PB.$5881.met1 9.3
Rext_2028 PB.$5702.li1 PB.$5706.li1 27.1058823529
Rext_2029 PB.$5702.li1 PB.$5882.met1 9.3
Rext_2030 PB.$5704.li1 PB.$5708.li1 27.1058823529
Rext_2031 PB.$5704.li1 PB.$5884.met1 9.3
Rext_2032 PB.$5706.li1 PB.$5710.li1 27.1058823529
Rext_2033 PB.$5706.li1 PB.$5885.met1 9.3
Rext_2034 PB.$5708.li1 PB.$5712.li1 27.1058823529
Rext_2035 PB.$5708.li1 PB.$5886.met1 9.3
Rext_2036 PB.$5710.li1 PB.$5714.li1 27.1058823529
Rext_2037 PB.$5710.li1 PB.$5887.met1 9.3
Rext_2038 PB.$5712.li1 PB.$5716.li1 27.1058823529
Rext_2039 PB.$5712.li1 PB.$5888.met1 9.3
Rext_2040 PB.$5714.li1 PB.$5718.li1 27.1058823529
Rext_2041 PB.$5714.li1 PB.$5889.met1 9.3
Rext_2042 PB.$5716.li1 PB.$5720.li1 27.1058823529
Rext_2043 PB.$5716.li1 PB.$5890.met1 9.3
Rext_2044 PB.$5718.li1 PB.$5722.li1 27.1058823529
Rext_2045 PB.$5718.li1 PB.$5891.met1 9.3
Rext_2046 PB.$5720.li1 PB.$5724.li1 27.1058823529
Rext_2047 PB.$5720.li1 PB.$5892.met1 9.3
Rext_2048 PB.$5722.li1 PB.$5726.li1 27.1058823529
Rext_2049 PB.$5722.li1 PB.$5893.met1 9.3
Rext_2050 PB.$5724.li1 PB.$5728.li1 27.1058823529
Rext_2051 PB.$5724.li1 PB.$5894.met1 9.3
Rext_2052 PB.$5726.li1 PB.$5730.li1 27.1058823529
Rext_2053 PB.$5726.li1 PB.$5895.met1 9.3
Rext_2054 PB.$5728.li1 PB.$5732.li1 27.1058823529
Rext_2055 PB.$5728.li1 PB.$5896.met1 9.3
Rext_2056 PB.$5730.li1 PB.$5734.li1 27.1058823529
Rext_2057 PB.$5730.li1 PB.$5897.met1 9.3
Rext_2058 PB.$5732.li1 PB.$5736.li1 27.1058823529
Rext_2059 PB.$5732.li1 PB.$5898.met1 9.3
Rext_2060 PB.$5734.li1 PB.$5738.li1 27.1058823529
Rext_2061 PB.$5734.li1 PB.$5899.met1 9.3
Rext_2062 PB.$5736.li1 PB.$5900.met1 9.3
Rext_2063 PB.$5738.li1 PB.$5901.met1 9.3
Rext_2064 PB.$5740.li1 PB.$5903.met1 9.3
Rext_2065 PB.$5740.li1 PB.P0.nsdm 185
Rext_2066 PB.$5742.li1 PB.$5744.li1 27.1058823529
Rext_2067 PB.$5742.li1 PB.$5904.met1 9.3
Rext_2068 PB.$5742.li1 PB.P0.psdm 585
Rext_2069 PB.$5744.li1 PB.$5746.li1 27.1058823529
Rext_2070 PB.$5744.li1 PB.$5905.met1 9.3
Rext_2071 PB.$5744.li1 PB.P0.psdm 585
Rext_2072 PB.$5746.li1 PB.$5748.li1 27.1058823529
Rext_2073 PB.$5746.li1 PB.$5906.met1 9.3
Rext_2074 PB.$5746.li1 PB.P0.psdm 585
Rext_2075 PB.$5748.li1 PB.$5750.li1 27.1058823529
Rext_2076 PB.$5748.li1 PB.$5907.met1 9.3
Rext_2077 PB.$5748.li1 PB.P0.psdm 585
Rext_2078 PB.$5750.li1 PB.$5752.li1 27.1058823529
Rext_2079 PB.$5750.li1 PB.$5908.met1 9.3
Rext_2080 PB.$5750.li1 PB.P0.psdm 585
Rext_2081 PB.$5752.li1 PB.$5754.li1 27.1058823529
Rext_2082 PB.$5752.li1 PB.$5909.met1 9.3
Rext_2083 PB.$5752.li1 PB.P0.psdm 585
Rext_2084 PB.$5754.li1 PB.$5756.li1 27.1058823529
Rext_2085 PB.$5754.li1 PB.$5910.met1 9.3
Rext_2086 PB.$5754.li1 PB.P0.psdm 585
Rext_2087 PB.$5756.li1 PB.$5758.li1 27.1058823529
Rext_2088 PB.$5756.li1 PB.$5911.met1 9.3
Rext_2089 PB.$5756.li1 PB.P0.psdm 585
Rext_2090 PB.$5758.li1 PB.$5760.li1 27.1058823529
Rext_2091 PB.$5758.li1 PB.$5912.met1 9.3
Rext_2092 PB.$5758.li1 PB.P0.psdm 585
Rext_2093 PB.$5760.li1 PB.$5762.li1 27.1058823529
Rext_2094 PB.$5760.li1 PB.$5913.met1 9.3
Rext_2095 PB.$5760.li1 PB.P0.psdm 585
Rext_2096 PB.$5762.li1 PB.$5914.met1 9.3
Rext_2097 PB.$5762.li1 PB.P0.psdm 585
Rext_2098 PB.$5764.met1 PB.$5766.met1 0.195652173913
Rext_2099 PB.$5765.met1 PB.$5767.met1 0.195652173913
Rext_2100 PB.$5766.met1 PB.$5768.met1 0.195652173913
Rext_2101 PB.$5767.met1 PB.$5769.met1 0.195652173913
Rext_2102 PB.$5768.met1 PB.$5770.met1 0.195652173913
Rext_2103 PB.$5769.met1 PB.$5771.met1 0.195652173913
Rext_2104 PB.$5770.met1 PB.$5772.met1 0.195652173913
Rext_2105 PB.$5771.met1 PB.$5773.met1 0.195652173913
Rext_2106 PB.$5772.met1 PB.$5774.met1 0.195652173913
Rext_2107 PB.$5773.met1 PB.$5775.met1 0.195652173913
Rext_2108 PB.$5774.met1 PB.$5776.met1 0.195652173913
Rext_2109 PB.$5775.met1 PB.$5777.met1 0.195652173913
Rext_2110 PB.$5776.met1 PB.$5778.met1 0.195652173913
Rext_2111 PB.$5777.met1 PB.$5779.met1 0.195652173913
Rext_2112 PB.$5778.met1 PB.$5780.met1 0.195652173913
Rext_2113 PB.$5779.met1 PB.$5781.met1 0.195652173913
Rext_2114 PB.$5780.met1 PB.$5783.met1 0.195652173913
Rext_2115 PB.$5781.met1 PB.$5782.met1 0.176630434783
Rext_2116 PB.$5782.met1 PB.$5784.met1 0.0190217391304
Rext_2117 PB.$5782.met1 PB.$5917.met2 4.5
Rext_2118 PB.$5783.met1 PB.$5785.met1 0.195652173913
Rext_2119 PB.$5784.met1 PB.$5786.met1 0.195652173913
Rext_2120 PB.$5787.met1 PB.$5789.met1 0.195652173913
Rext_2121 PB.$5788.met1 PB.$5790.met1 0.195652173913
Rext_2122 PB.$5789.met1 PB.$5792.met1 0.195652173913
Rext_2123 PB.$5790.met1 PB.$5791.met1 0.133152173913
Rext_2124 PB.$5791.met1 PB.$5793.met1 0.0625
Rext_2125 PB.$5791.met1 PB.$5919.met2 4.5
Rext_2126 PB.$5792.met1 PB.$5794.met1 0.195652173913
Rext_2127 PB.$5793.met1 PB.$5795.met1 0.195652173913
Rext_2128 PB.$5794.met1 PB.$5796.met1 0.195652173913
Rext_2129 PB.$5795.met1 PB.$5797.met1 0.195652173913
Rext_2130 PB.$5796.met1 PB.$5798.met1 0.195652173913
Rext_2131 PB.$5797.met1 PB.$5799.met1 0.195652173913
Rext_2132 PB.$5798.met1 PB.$5800.met1 0.195652173913
Rext_2133 PB.$5799.met1 PB.$5801.met1 0.195652173913
Rext_2134 PB.$5800.met1 PB.$5802.met1 0.195652173913
Rext_2135 PB.$5801.met1 PB.$5803.met1 0.195652173913
Rext_2136 PB.$5802.met1 PB.$5804.met1 0.195652173913
Rext_2137 PB.$5803.met1 PB.$5805.met1 0.195652173913
Rext_2138 PB.$5804.met1 PB.$5806.met1 0.195652173913
Rext_2139 PB.$5805.met1 PB.$5807.met1 0.195652173913
Rext_2140 PB.$5806.met1 PB.$5853.met1 0.195652173913
Rext_2141 PB.$5807.met1 PB.$5854.met1 0.195652173913
Rext_2142 PB.$5808.met1 PB.$5852.met1 0.165760869565
Rext_2143 PB.$5809.met1 PB.$5810.met1 0.195652173913
Rext_2144 PB.$5809.met1 PB.$5852.met1 0.0298913043478
Rext_2145 PB.$5810.met1 PB.$5811.met1 0.195652173913
Rext_2146 PB.$5811.met1 PB.$5812.met1 0.195652173913
Rext_2147 PB.$5812.met1 PB.$5813.met1 0.195652173913
Rext_2148 PB.$5813.met1 PB.$5814.met1 0.195652173913
Rext_2149 PB.$5814.met1 PB.$5815.met1 0.195652173913
Rext_2150 PB.$5815.met1 PB.$5816.met1 0.195652173913
Rext_2151 PB.$5816.met1 PB.$5817.met1 0.195652173913
Rext_2152 PB.$5817.met1 PB.$5818.met1 0.195652173913
Rext_2153 PB.$5818.met1 PB.$5819.met1 0.195652173913
Rext_2154 PB.$5819.met1 PB.$5820.met1 0.195652173913
Rext_2155 PB.$5820.met1 PB.$5821.met1 0.195652173913
Rext_2156 PB.$5821.met1 PB.$5822.met1 0.195652173913
Rext_2157 PB.$5822.met1 PB.$5823.met1 0.195652173913
Rext_2158 PB.$5823.met1 PB.$5824.met1 0.195652173913
Rext_2159 PB.$5824.met1 PB.$5825.met1 0.195652173913
Rext_2160 PB.$5825.met1 PB.$5826.met1 0.195652173913
Rext_2161 PB.$5826.met1 PB.$5827.met1 0.195652173913
Rext_2162 PB.$5827.met1 PB.$5828.met1 0.195652173913
Rext_2163 PB.$5828.met1 PB.$5829.met1 0.195652173913
Rext_2164 PB.$5829.met1 PB.$5830.met1 0.195652173913
Rext_2165 PB.$5830.met1 PB.$5831.met1 0.195652173913
Rext_2166 PB.$5831.met1 PB.$5832.met1 0.195652173913
Rext_2167 PB.$5832.met1 PB.$5833.met1 0.195652173913
Rext_2168 PB.$5833.met1 PB.$5834.met1 0.195652173913
Rext_2169 PB.$5834.met1 PB.$5835.met1 0.195652173913
Rext_2170 PB.$5835.met1 PB.$5836.met1 0.195652173913
Rext_2171 PB.$5836.met1 PB.$5837.met1 0.195652173913
Rext_2172 PB.$5837.met1 PB.$5838.met1 0.195652173913
Rext_2173 PB.$5838.met1 PB.$5839.met1 0.195652173913
Rext_2174 PB.$5839.met1 PB.$5840.met1 0.195652173913
Rext_2175 PB.$5840.met1 PB.$5841.met1 0.195652173913
Rext_2176 PB.$5841.met1 PB.$5842.met1 0.195652173913
Rext_2177 PB.$5842.met1 PB.$5843.met1 0.195652173913
Rext_2178 PB.$5843.met1 PB.$5844.met1 0.195652173913
Rext_2179 PB.$5844.met1 PB.$5845.met1 0.195652173913
Rext_2180 PB.$5845.met1 PB.$5846.met1 0.195652173913
Rext_2181 PB.$5846.met1 PB.$5847.met1 0.195652173913
Rext_2182 PB.$5847.met1 PB.$5848.met1 0.195652173913
Rext_2183 PB.$5848.met1 PB.$5849.met1 0.195652173913
Rext_2184 PB.$5849.met1 PB.$5850.met1 0.195652173913
Rext_2185 PB.$5850.met1 PB.$5851.met1 0.195652173913
Rext_2186 PB.$5852.met1 PB.$5920.met2 4.5
Rext_2187 PB.$5855.met1 PB.$5857.met1 0.0102811735206
Rext_2188 PB.$5855.met1 PB.$5858.met1 0.00288431626249
Rext_2189 PB.$5855.met1 PB.$5860.met1 0.218494527062
Rext_2190 PB.$5856.met1 PB.$5859.met1 0.195652173913
Rext_2191 PB.$5858.met1 PB.$5923.met2 4.5
Rext_2192 PB.$5859.met1 PB.$5861.met1 0.195652173913
Rext_2193 PB.$5860.met1 PB.$5862.met1 0.195652173913
Rext_2194 PB.$5861.met1 PB.$5863.met1 0.195652173913
Rext_2195 PB.$5862.met1 PB.$5864.met1 0.195652173913
Rext_2196 PB.$5863.met1 PB.$5865.met1 0.195652173913
Rext_2197 PB.$5864.met1 PB.$5866.met1 0.195652173913
Rext_2198 PB.$5865.met1 PB.$5867.met1 0.195652173913
Rext_2199 PB.$5866.met1 PB.$5868.met1 0.195652173913
Rext_2200 PB.$5867.met1 PB.$5869.met1 0.195652173913
Rext_2201 PB.$5868.met1 PB.$5870.met1 0.195652173913
Rext_2202 PB.$5869.met1 PB.$5871.met1 0.195652173913
Rext_2203 PB.$5870.met1 PB.$5872.met1 0.195652173913
Rext_2204 PB.$5871.met1 PB.$5873.met1 0.195652173913
Rext_2205 PB.$5872.met1 PB.$5874.met1 0.195652173913
Rext_2206 PB.$5873.met1 PB.$5875.met1 0.195652173913
Rext_2207 PB.$5874.met1 PB.$5876.met1 0.195652173913
Rext_2208 PB.$5875.met1 PB.$5877.met1 0.195652173913
Rext_2209 PB.$5876.met1 PB.$5878.met1 0.195652173913
Rext_2210 PB.$5879.met1 PB.$5881.met1 0.195652173913
Rext_2211 PB.$5880.met1 PB.$5882.met1 0.195652173913
Rext_2212 PB.$5881.met1 PB.$5884.met1 0.195652173913
Rext_2213 PB.$5882.met1 PB.$5883.met1 0.0244565217391
Rext_2214 PB.$5883.met1 PB.$5885.met1 0.171195652174
Rext_2215 PB.$5883.met1 PB.$5926.met2 4.5
Rext_2216 PB.$5884.met1 PB.$5886.met1 0.195652173913
Rext_2217 PB.$5885.met1 PB.$5887.met1 0.195652173913
Rext_2218 PB.$5886.met1 PB.$5888.met1 0.195652173913
Rext_2219 PB.$5887.met1 PB.$5889.met1 0.195652173913
Rext_2220 PB.$5888.met1 PB.$5890.met1 0.195652173913
Rext_2221 PB.$5889.met1 PB.$5891.met1 0.195652173913
Rext_2222 PB.$5890.met1 PB.$5892.met1 0.195652173913
Rext_2223 PB.$5891.met1 PB.$5893.met1 0.195652173913
Rext_2224 PB.$5892.met1 PB.$5894.met1 0.195652173913
Rext_2225 PB.$5893.met1 PB.$5895.met1 0.195652173913
Rext_2226 PB.$5894.met1 PB.$5896.met1 0.195652173913
Rext_2227 PB.$5895.met1 PB.$5897.met1 0.195652173913
Rext_2228 PB.$5896.met1 PB.$5898.met1 0.195652173913
Rext_2229 PB.$5897.met1 PB.$5899.met1 0.195652173913
Rext_2230 PB.$5898.met1 PB.$5900.met1 0.195652173913
Rext_2231 PB.$5899.met1 PB.$5901.met1 0.195652173913
Rext_2232 PB.$5902.met1 PB.$5903.met1 0.0520161181075
Rext_2233 PB.$5902.met1 PB.$5930.met2 4.5
Rext_2234 PB.$5904.met1 PB.$5915.met1 0.0570652173913
Rext_2235 PB.$5905.met1 PB.$5906.met1 0.195652173913
Rext_2236 PB.$5905.met1 PB.$5915.met1 0.138586956522
Rext_2237 PB.$5906.met1 PB.$5907.met1 0.195652173913
Rext_2238 PB.$5907.met1 PB.$5908.met1 0.195652173913
Rext_2239 PB.$5908.met1 PB.$5909.met1 0.195652173913
Rext_2240 PB.$5909.met1 PB.$5910.met1 0.195652173913
Rext_2241 PB.$5910.met1 PB.$5911.met1 0.195652173913
Rext_2242 PB.$5911.met1 PB.$5912.met1 0.195652173913
Rext_2243 PB.$5912.met1 PB.$5913.met1 0.195652173913
Rext_2244 PB.$5913.met1 PB.$5914.met1 0.195652173913
Rext_2245 PB.$5915.met1 PB.$5931.met2 4.5
Rext_2246 PB.$5916.met2 PB.$5917.met2 0.003125
Rext_2247 PB.$5916.met2 PB.$5934.met3 3.41
Rext_2248 PB.$5918.met2 PB.$5919.met2 0.003125
Rext_2249 PB.$5918.met2 PB.$5935.met3 3.41
Rext_2250 PB.$592.capm PB.$6539.met4 0.0460810810811
Rext_2251 PB.$592.capm PB.$666.capm 0.0773333333333
Rext_2252 PB.$5920.met2 PB.$5921.met2 0.98554816065
Rext_2253 PB.$5921.met2 PB.$5936.met3 3.41
Rext_2254 PB.$5922.met2 PB.$5923.met2 0.003125
Rext_2255 PB.$5922.met2 PB.$5937.met3 3.41
Rext_2256 PB.$5924.met2 PB.$5925.met2 2.52414339757
Rext_2257 PB.$5924.met2 PB.$5938.met3 3.41
Rext_2258 PB.$5925.met2 PB.$5926.met2 0.00609877052118
Rext_2259 PB.$5925.met2 PB.$5939.met3 3.41
Rext_2260 PB.$5927.met2 PB.$5928.met2 5
Rext_2261 PB.$5927.met2 PB.$5940.met3 3.41
Rext_2262 PB.$5928.met2 PB.$5930.met2 0.87325266948
Rext_2263 PB.$5928.met2 PB.$5942.met3 3.41
Rext_2264 PB.$5929.met2 PB.$5930.met2 0.124715069938
Rext_2265 PB.$5929.met2 PB.$5943.met3 3.41
Rext_2266 PB.$5931.met2 PB.$5933.met2 0.0744320749586
Rext_2267 PB.$5932.met2 PB.$5933.met2 6.58617350645
Rext_2268 PB.$5932.met2 PB.$5944.met3 3.41
Rext_2269 PB.$5933.met2 PB.$5945.met3 3.41
Rext_2270 PB.$5934.met3 PB.$5935.met3 0.52875
Rext_2271 PB.$5935.met3 PB.$5937.met3 0.74025
Rext_2272 PB.$5936.met3 PB.$5942.met3 2.43225
Rext_2273 PB.$5937.met3 PB.$5939.met3 0.846
Rext_2274 PB.$5938.met3 PB.$5945.met3 2.00925
Rext_2275 PB.$5940.met3 PB.$5946.met4 3.41
Rext_2276 PB.$5943.met3 PB.$5944.met3 0.846
Rext_2277 PB.$5946.met4 PB.$5947.met4 0.188325396825
Rext_2278 PB.$5947.met4 PB.$6021.met4 0.000634920634921
Rext_2279 PB.$6095.met4 PB.$6169.met4 0.000634920634921
Rext_2280 PB.$6169.met4 PB.$6243.met4 0.000634920634921
Rext_2281 PB.$6243.met4 PB.$6317.met4 0.000634920634921
Rext_2282 PB.$6317.met4 PB.$6391.met4 0.000634920634921
Rext_2283 PB.$6391.met4 PB.$6465.met4 0.000634920634921
Rext_2284 PB.$6465.met4 PB.$6539.met4 0.000634920634921
Rext_2285 PB.$6539.met4 PB.$6613.met4 0.000634920634921
Rext_2286 PB.$6613.met4 PB.$666.capm 0.0460810810811
Rext_2287 PB.$6613.met4 PB.$6687.met4 0.000634920634921
Rext_2288 PB.$666.capm PB.$740.capm 0.0773333333333
Rext_2289 PB.$6687.met4 PB.$6761.met4 0.000634920634921
Rext_2290 PB.$6687.met4 PB.$740.capm 0.0460810810811
Rext_2291 PB.$6761.met4 PB.$6835.met4 0.000634920634921
Rext_2292 PB.$6761.met4 PB.$814.capm 0.0460810810811
Rext_2293 PB.$6835.met4 PB.$6909.met4 0.000634920634921
Rext_2294 PB.$6835.met4 PB.$888.capm 0.0460810810811
Rext_2295 PB.$6909.met4 PB.$6983.met4 0.000634920634921
Rext_2296 PB.$6983.met4 PB.$7057.met4 0.000634920634921
Rext_2297 PB.$7057.met4 PB.$7131.met4 0.000634920634921
Rext_2298 PB.$7131.met4 PB.$7205.met4 0.000634920634921
Rext_2299 PB.$7205.met4 PB.$7279.met4 0.000634920634921
Rext_2300 PB.$7279.met4 PB.$7353.met4 0.000634920634921
Rext_2301 PB.$7353.met4 PB.$7427.met4 0.000634920634921
Rext_2302 PB.$740.capm PB.$814.capm 0.0773333333333
Rext_2303 PB.$7427.met4 PB.$7501.met4 0.000634920634921
Rext_2304 PB.$7501.met4 PB.$7575.met4 0.000634920634921
Rext_2305 PB.$7575.met4 PB.$7649.met4 0.000634920634921
Rext_2306 PB.$7649.met4 PB.$7723.met4 0.000634920634921
Rext_2307 PB.$7723.met4 PB.$7797.met4 0.000634920634921
Rext_2308 PB.$7797.met4 PB.$7871.met4 0.000634920634921
Rext_2309 PB.$7871.met4 PB.$7945.met4 0.000634920634921
Rext_2310 PB.$7945.met4 PB.$8019.met4 0.000634920634921
Rext_2311 PB.$8019.met4 PB.$8093.met4 0.000634920634921
Rext_2312 PB.$8093.met4 PB.$8167.met4 0.000634920634921
Rext_2313 PB.$814.capm PB.$888.capm 0.0773333333333
Rext_2314 PB.$8167.met4 PB.$8241.met4 0.000634920634921
Rext_2315 PB.$8241.met4 PB.$8315.met4 0.000634920634921
Rext_2316 PB.$8315.met4 PB.$8389.met4 0.000634920634921
Rext_2317 PB.$8389.met4 PB.$8463.met4 0.000634920634921
Rext_2318 PB.$8463.met4 PB.$8537.met4 0.000634920634921
Rext_2319 PB.$8537.met4 PB.$8611.met4 0.000634920634921
Rext_2320 PB.$8611.met4 PB.$8685.met4 0.000634920634921
Rext_2321 PB.$8685.met4 PB.$8759.met4 0.000634920634921
Rext_2322 PB.$8759.met4 PB.$8833.met4 0.000634920634921
Rext_2323 PB.$8833.met4 PB.$8907.met4 0.000634920634921
Rext_2324 PB.$8907.met4 PB.$8981.met4 0.000634920634921
Rext_2325 PB.$8981.met4 PB.$9055.met4 0.000634920634921
Rext_2326 PB.$9055.met4 PB.$9129.met4 0.000634920634921
Rext_2327 PB.$9129.met4 PB.$9203.met4 0.000634920634921
Rext_2328 PB.$9203.met4 PB.$9277.met4 0.000634920634921
Rext_2329 PB.$9277.met4 PB.$9351.met4 0.000634920634921
Rext_2330 PB.$9351.met4 PB.$9425.met4 0.000634920634921
Rext_2331 PB.$9425.met4 PB.$9499.met4 0.000634920634921
Rext_2332 PB.$9499.met4 PB.$9573.met4 0.000634920634921
Rext_2333 PB.$9573.met4 PB.$9647.met4 0.000634920634921
Rext_2334 PB.$9647.met4 PB.$9721.met4 0.000634920634921
Rext_2335 PB.$9721.met4 PB.$9795.met4 0.000634920634921
Rext_2336 PB.$9795.met4 PB.$9869.met4 0.000634920634921
Rext_2337 S S.$30.met2 0.068848765357
Rext_2338 S S.$31.met2 1.31232021126
Rext_2339 S.$0.li1 S.$18.met1 9.3
Rext_2340 S.$0.li1 S.$2.li1 27.1058823529
Rext_2341 S.$0.li1 S.P0.nsdm 185
Rext_2342 S.$10.li1 S.$14.li1 27.1058823529
Rext_2343 S.$10.li1 S.$25.met1 9.3
Rext_2344 S.$10.li1 S.$40.poly 152
Rext_2345 S.$10.li1 S.$6.li1 27.1058823529
Rext_2346 S.$12.li1 S.$26.met1 9.3
Rext_2347 S.$12.li1 S.$39.poly 152
Rext_2348 S.$12.li1 S.$8.li1 27.1058823529
Rext_2349 S.$14.li1 S.$27.met1 9.3
Rext_2350 S.$14.li1 S.$40.poly 152
Rext_2351 S.$16.li1 S.$29.met1 9.3
Rext_2352 S.$16.li1 S.P0.psdm 585
Rext_2353 S.$18.met1 S.$20.met1 0.138586956522
Rext_2354 S.$19.met1 S.$2.li1 9.3
Rext_2355 S.$19.met1 S.$20.met1 0.0570652173913
Rext_2356 S.$2.li1 S.P0.nsdm 185
Rext_2357 S.$20.met1 S.$30.met2 4.5
Rext_2358 S.$21.met1 S.$22.met1 0.0308439976478
Rext_2359 S.$21.met1 S.$32.met2 4.5
Rext_2360 S.$22.met1 S.$24.met1 0.213203777285
Rext_2361 S.$22.met1 S.$4.li1 9.3
Rext_2362 S.$23.met1 S.$25.met1 0.195652173913
Rext_2363 S.$23.met1 S.$6.li1 9.3
Rext_2364 S.$24.met1 S.$26.met1 0.195652173913
Rext_2365 S.$24.met1 S.$8.li1 9.3
Rext_2366 S.$25.met1 S.$27.met1 0.195652173913
Rext_2367 S.$28.met1 S.$29.met1 0.0730710282136
Rext_2368 S.$28.met1 S.$34.met2 4.5
Rext_2369 S.$31.met2 S.$32.met2 0.011927105293
Rext_2370 S.$31.met2 S.$35.met3 3.41
Rext_2371 S.$33.met2 S.$34.met2 6.98922915878
Rext_2372 S.$33.met2 S.$36.met3 3.41
Rext_2373 S.$35.met3 S.$36.met3 2.115
Rext_2374 S.$39.poly S.$4.li1 152
Rext_2375 S.$39.poly S.$8.li1 152
Rext_2376 S.$39.poly S.P0.poly 27.715
Rext_2377 S.$4.li1 S.$8.li1 27.1058823529
Rext_2378 S.$40.poly S.$6.li1 152
Rext_2379 S.$40.poly S.P0.poly 27.715
Rext_2380 TAIL TAIL.$338.met2 0.0180722891566
Rext_2381 TAIL TAIL.$341.met3 3.41
Rext_2382 TAIL.$0.li1 TAIL.$2.li1 27.1058823529
Rext_2383 TAIL.$0.li1 TAIL.$221.met1 9.3
Rext_2384 TAIL.$0.li1 TAIL.P1.nsdm 185
Rext_2385 TAIL.$10.li1 TAIL.$12.li1 27.1058823529
Rext_2386 TAIL.$10.li1 TAIL.$226.met1 9.3
Rext_2387 TAIL.$10.li1 TAIL.$8.li1 27.1058823529
Rext_2388 TAIL.$10.li1 TAIL.P1.nsdm 185
Rext_2389 TAIL.$100.li1 TAIL.$102.li1 27.1058823529
Rext_2390 TAIL.$100.li1 TAIL.$271.met1 9.3
Rext_2391 TAIL.$100.li1 TAIL.$98.li1 27.1058823529
Rext_2392 TAIL.$100.li1 TAIL.P2.nsdm 185
Rext_2393 TAIL.$102.li1 TAIL.$104.li1 27.1058823529
Rext_2394 TAIL.$102.li1 TAIL.$272.met1 9.3
Rext_2395 TAIL.$102.li1 TAIL.P2.nsdm 185
Rext_2396 TAIL.$104.li1 TAIL.$106.li1 27.1058823529
Rext_2397 TAIL.$104.li1 TAIL.$273.met1 9.3
Rext_2398 TAIL.$104.li1 TAIL.P2.nsdm 185
Rext_2399 TAIL.$106.li1 TAIL.$108.li1 27.1058823529
Rext_2400 TAIL.$106.li1 TAIL.$274.met1 9.3
Rext_2401 TAIL.$106.li1 TAIL.P2.nsdm 185
Rext_2402 TAIL.$108.li1 TAIL.$110.li1 27.1058823529
Rext_2403 TAIL.$108.li1 TAIL.$275.met1 9.3
Rext_2404 TAIL.$108.li1 TAIL.P2.nsdm 185
Rext_2405 TAIL.$110.li1 TAIL.$112.li1 27.1058823529
Rext_2406 TAIL.$110.li1 TAIL.$276.met1 9.3
Rext_2407 TAIL.$110.li1 TAIL.P2.nsdm 185
Rext_2408 TAIL.$112.li1 TAIL.$114.li1 27.1058823529
Rext_2409 TAIL.$112.li1 TAIL.$277.met1 9.3
Rext_2410 TAIL.$112.li1 TAIL.P2.nsdm 185
Rext_2411 TAIL.$114.li1 TAIL.$116.li1 27.1058823529
Rext_2412 TAIL.$114.li1 TAIL.$278.met1 9.3
Rext_2413 TAIL.$114.li1 TAIL.P2.nsdm 185
Rext_2414 TAIL.$116.li1 TAIL.$118.li1 27.1058823529
Rext_2415 TAIL.$116.li1 TAIL.$279.met1 9.3
Rext_2416 TAIL.$116.li1 TAIL.P2.nsdm 185
Rext_2417 TAIL.$118.li1 TAIL.$120.li1 27.1058823529
Rext_2418 TAIL.$118.li1 TAIL.$280.met1 9.3
Rext_2419 TAIL.$118.li1 TAIL.P2.nsdm 185
Rext_2420 TAIL.$12.li1 TAIL.$14.li1 27.1058823529
Rext_2421 TAIL.$12.li1 TAIL.$227.met1 9.3
Rext_2422 TAIL.$12.li1 TAIL.P1.nsdm 185
Rext_2423 TAIL.$120.li1 TAIL.$122.li1 27.1058823529
Rext_2424 TAIL.$120.li1 TAIL.$281.met1 9.3
Rext_2425 TAIL.$120.li1 TAIL.P2.nsdm 185
Rext_2426 TAIL.$122.li1 TAIL.$124.li1 27.1058823529
Rext_2427 TAIL.$122.li1 TAIL.$282.met1 9.3
Rext_2428 TAIL.$122.li1 TAIL.P2.nsdm 185
Rext_2429 TAIL.$124.li1 TAIL.$126.li1 27.1058823529
Rext_2430 TAIL.$124.li1 TAIL.$283.met1 9.3
Rext_2431 TAIL.$124.li1 TAIL.P2.nsdm 185
Rext_2432 TAIL.$126.li1 TAIL.$128.li1 27.1058823529
Rext_2433 TAIL.$126.li1 TAIL.$284.met1 9.3
Rext_2434 TAIL.$126.li1 TAIL.P2.nsdm 185
Rext_2435 TAIL.$128.li1 TAIL.$130.li1 27.1058823529
Rext_2436 TAIL.$128.li1 TAIL.$285.met1 9.3
Rext_2437 TAIL.$128.li1 TAIL.P2.nsdm 185
Rext_2438 TAIL.$130.li1 TAIL.$132.li1 27.1058823529
Rext_2439 TAIL.$130.li1 TAIL.$286.met1 9.3
Rext_2440 TAIL.$130.li1 TAIL.P2.nsdm 185
Rext_2441 TAIL.$132.li1 TAIL.$134.li1 27.1058823529
Rext_2442 TAIL.$132.li1 TAIL.$287.met1 9.3
Rext_2443 TAIL.$132.li1 TAIL.P2.nsdm 185
Rext_2444 TAIL.$134.li1 TAIL.$136.li1 27.1058823529
Rext_2445 TAIL.$134.li1 TAIL.$288.met1 9.3
Rext_2446 TAIL.$134.li1 TAIL.P2.nsdm 185
Rext_2447 TAIL.$136.li1 TAIL.$138.li1 27.1058823529
Rext_2448 TAIL.$136.li1 TAIL.$289.met1 9.3
Rext_2449 TAIL.$136.li1 TAIL.P2.nsdm 185
Rext_2450 TAIL.$138.li1 TAIL.$140.li1 27.1058823529
Rext_2451 TAIL.$138.li1 TAIL.$290.met1 9.3
Rext_2452 TAIL.$138.li1 TAIL.P2.nsdm 185
Rext_2453 TAIL.$14.li1 TAIL.$16.li1 27.1058823529
Rext_2454 TAIL.$14.li1 TAIL.$228.met1 9.3
Rext_2455 TAIL.$14.li1 TAIL.P1.nsdm 185
Rext_2456 TAIL.$140.li1 TAIL.$142.li1 27.1058823529
Rext_2457 TAIL.$140.li1 TAIL.$291.met1 9.3
Rext_2458 TAIL.$140.li1 TAIL.P2.nsdm 185
Rext_2459 TAIL.$142.li1 TAIL.$144.li1 27.1058823529
Rext_2460 TAIL.$142.li1 TAIL.$292.met1 9.3
Rext_2461 TAIL.$142.li1 TAIL.P2.nsdm 185
Rext_2462 TAIL.$144.li1 TAIL.$146.li1 27.1058823529
Rext_2463 TAIL.$144.li1 TAIL.$293.met1 9.3
Rext_2464 TAIL.$144.li1 TAIL.P2.nsdm 185
Rext_2465 TAIL.$146.li1 TAIL.$148.li1 27.1058823529
Rext_2466 TAIL.$146.li1 TAIL.$294.met1 9.3
Rext_2467 TAIL.$146.li1 TAIL.P2.nsdm 185
Rext_2468 TAIL.$148.li1 TAIL.$150.li1 27.1058823529
Rext_2469 TAIL.$148.li1 TAIL.$295.met1 9.3
Rext_2470 TAIL.$148.li1 TAIL.P2.nsdm 185
Rext_2471 TAIL.$150.li1 TAIL.$152.li1 27.1058823529
Rext_2472 TAIL.$150.li1 TAIL.$296.met1 9.3
Rext_2473 TAIL.$150.li1 TAIL.P2.nsdm 185
Rext_2474 TAIL.$152.li1 TAIL.$154.li1 27.1058823529
Rext_2475 TAIL.$152.li1 TAIL.$297.met1 9.3
Rext_2476 TAIL.$152.li1 TAIL.P2.nsdm 185
Rext_2477 TAIL.$154.li1 TAIL.$156.li1 27.1058823529
Rext_2478 TAIL.$154.li1 TAIL.$298.met1 9.3
Rext_2479 TAIL.$154.li1 TAIL.P2.nsdm 185
Rext_2480 TAIL.$156.li1 TAIL.$158.li1 27.1058823529
Rext_2481 TAIL.$156.li1 TAIL.$299.met1 9.3
Rext_2482 TAIL.$156.li1 TAIL.P2.nsdm 185
Rext_2483 TAIL.$158.li1 TAIL.$160.li1 27.1058823529
Rext_2484 TAIL.$158.li1 TAIL.$300.met1 9.3
Rext_2485 TAIL.$158.li1 TAIL.P2.nsdm 185
Rext_2486 TAIL.$16.li1 TAIL.$18.li1 27.1058823529
Rext_2487 TAIL.$16.li1 TAIL.$229.met1 9.3
Rext_2488 TAIL.$16.li1 TAIL.P1.nsdm 185
Rext_2489 TAIL.$160.li1 TAIL.$162.li1 27.1058823529
Rext_2490 TAIL.$160.li1 TAIL.$301.met1 9.3
Rext_2491 TAIL.$160.li1 TAIL.P2.nsdm 185
Rext_2492 TAIL.$162.li1 TAIL.$164.li1 27.1058823529
Rext_2493 TAIL.$162.li1 TAIL.$302.met1 9.3
Rext_2494 TAIL.$162.li1 TAIL.P2.nsdm 185
Rext_2495 TAIL.$164.li1 TAIL.$166.li1 27.1058823529
Rext_2496 TAIL.$164.li1 TAIL.$303.met1 9.3
Rext_2497 TAIL.$164.li1 TAIL.P2.nsdm 185
Rext_2498 TAIL.$166.li1 TAIL.$168.li1 27.1058823529
Rext_2499 TAIL.$166.li1 TAIL.$304.met1 9.3
Rext_2500 TAIL.$166.li1 TAIL.P2.nsdm 185
Rext_2501 TAIL.$168.li1 TAIL.$170.li1 27.1058823529
Rext_2502 TAIL.$168.li1 TAIL.$305.met1 9.3
Rext_2503 TAIL.$168.li1 TAIL.P2.nsdm 185
Rext_2504 TAIL.$170.li1 TAIL.$172.li1 27.1058823529
Rext_2505 TAIL.$170.li1 TAIL.$306.met1 9.3
Rext_2506 TAIL.$170.li1 TAIL.P2.nsdm 185
Rext_2507 TAIL.$172.li1 TAIL.$174.li1 27.1058823529
Rext_2508 TAIL.$172.li1 TAIL.$307.met1 9.3
Rext_2509 TAIL.$172.li1 TAIL.P2.nsdm 185
Rext_2510 TAIL.$174.li1 TAIL.$308.met1 9.3
Rext_2511 TAIL.$174.li1 TAIL.P2.nsdm 185
Rext_2512 TAIL.$176.li1 TAIL.$178.li1 27.1058823529
Rext_2513 TAIL.$176.li1 TAIL.$311.met1 9.3
Rext_2514 TAIL.$176.li1 TAIL.P0.nsdm 185
Rext_2515 TAIL.$178.li1 TAIL.$180.li1 27.1058823529
Rext_2516 TAIL.$178.li1 TAIL.$312.met1 9.3
Rext_2517 TAIL.$178.li1 TAIL.P0.nsdm 185
Rext_2518 TAIL.$18.li1 TAIL.$20.li1 27.1058823529
Rext_2519 TAIL.$18.li1 TAIL.$230.met1 9.3
Rext_2520 TAIL.$18.li1 TAIL.P1.nsdm 185
Rext_2521 TAIL.$180.li1 TAIL.$182.li1 27.1058823529
Rext_2522 TAIL.$180.li1 TAIL.$313.met1 9.3
Rext_2523 TAIL.$180.li1 TAIL.P0.nsdm 185
Rext_2524 TAIL.$182.li1 TAIL.$184.li1 27.1058823529
Rext_2525 TAIL.$182.li1 TAIL.$314.met1 9.3
Rext_2526 TAIL.$182.li1 TAIL.P0.nsdm 185
Rext_2527 TAIL.$184.li1 TAIL.$186.li1 27.1058823529
Rext_2528 TAIL.$184.li1 TAIL.$315.met1 9.3
Rext_2529 TAIL.$184.li1 TAIL.P0.nsdm 185
Rext_2530 TAIL.$186.li1 TAIL.$188.li1 27.1058823529
Rext_2531 TAIL.$186.li1 TAIL.$316.met1 9.3
Rext_2532 TAIL.$186.li1 TAIL.P0.nsdm 185
Rext_2533 TAIL.$188.li1 TAIL.$190.li1 27.1058823529
Rext_2534 TAIL.$188.li1 TAIL.$317.met1 9.3
Rext_2535 TAIL.$188.li1 TAIL.P0.nsdm 185
Rext_2536 TAIL.$190.li1 TAIL.$192.li1 27.1058823529
Rext_2537 TAIL.$190.li1 TAIL.$318.met1 9.3
Rext_2538 TAIL.$190.li1 TAIL.P0.nsdm 185
Rext_2539 TAIL.$192.li1 TAIL.$194.li1 27.1058823529
Rext_2540 TAIL.$192.li1 TAIL.$319.met1 9.3
Rext_2541 TAIL.$192.li1 TAIL.P0.nsdm 185
Rext_2542 TAIL.$194.li1 TAIL.$196.li1 27.1058823529
Rext_2543 TAIL.$194.li1 TAIL.$320.met1 9.3
Rext_2544 TAIL.$194.li1 TAIL.P0.nsdm 185
Rext_2545 TAIL.$196.li1 TAIL.$198.li1 27.1058823529
Rext_2546 TAIL.$196.li1 TAIL.$321.met1 9.3
Rext_2547 TAIL.$196.li1 TAIL.P0.nsdm 185
Rext_2548 TAIL.$198.li1 TAIL.$200.li1 27.1058823529
Rext_2549 TAIL.$198.li1 TAIL.$322.met1 9.3
Rext_2550 TAIL.$198.li1 TAIL.P0.nsdm 185
Rext_2551 TAIL.$2.li1 TAIL.$222.met1 9.3
Rext_2552 TAIL.$2.li1 TAIL.$4.li1 27.1058823529
Rext_2553 TAIL.$2.li1 TAIL.P1.nsdm 185
Rext_2554 TAIL.$20.li1 TAIL.$22.li1 27.1058823529
Rext_2555 TAIL.$20.li1 TAIL.$231.met1 9.3
Rext_2556 TAIL.$20.li1 TAIL.P1.nsdm 185
Rext_2557 TAIL.$200.li1 TAIL.$202.li1 27.1058823529
Rext_2558 TAIL.$200.li1 TAIL.$323.met1 9.3
Rext_2559 TAIL.$200.li1 TAIL.P0.nsdm 185
Rext_2560 TAIL.$202.li1 TAIL.$204.li1 27.1058823529
Rext_2561 TAIL.$202.li1 TAIL.$324.met1 9.3
Rext_2562 TAIL.$202.li1 TAIL.P0.nsdm 185
Rext_2563 TAIL.$204.li1 TAIL.$206.li1 27.1058823529
Rext_2564 TAIL.$204.li1 TAIL.$325.met1 9.3
Rext_2565 TAIL.$204.li1 TAIL.P0.nsdm 185
Rext_2566 TAIL.$206.li1 TAIL.$208.li1 27.1058823529
Rext_2567 TAIL.$206.li1 TAIL.$326.met1 9.3
Rext_2568 TAIL.$206.li1 TAIL.P0.nsdm 185
Rext_2569 TAIL.$208.li1 TAIL.$210.li1 27.1058823529
Rext_2570 TAIL.$208.li1 TAIL.$327.met1 9.3
Rext_2571 TAIL.$208.li1 TAIL.P0.nsdm 185
Rext_2572 TAIL.$210.li1 TAIL.$212.li1 27.1058823529
Rext_2573 TAIL.$210.li1 TAIL.$328.met1 9.3
Rext_2574 TAIL.$210.li1 TAIL.P0.nsdm 185
Rext_2575 TAIL.$212.li1 TAIL.$214.li1 27.1058823529
Rext_2576 TAIL.$212.li1 TAIL.$329.met1 9.3
Rext_2577 TAIL.$212.li1 TAIL.P0.nsdm 185
Rext_2578 TAIL.$214.li1 TAIL.$216.li1 27.1058823529
Rext_2579 TAIL.$214.li1 TAIL.$330.met1 9.3
Rext_2580 TAIL.$214.li1 TAIL.P0.nsdm 185
Rext_2581 TAIL.$216.li1 TAIL.$218.li1 27.1058823529
Rext_2582 TAIL.$216.li1 TAIL.$331.met1 9.3
Rext_2583 TAIL.$216.li1 TAIL.P0.nsdm 185
Rext_2584 TAIL.$218.li1 TAIL.$332.met1 9.3
Rext_2585 TAIL.$218.li1 TAIL.P0.nsdm 185
Rext_2586 TAIL.$22.li1 TAIL.$232.met1 9.3
Rext_2587 TAIL.$22.li1 TAIL.$24.li1 27.1058823529
Rext_2588 TAIL.$22.li1 TAIL.P1.nsdm 185
Rext_2589 TAIL.$220.met1 TAIL.$221.met1 0.165760869565
Rext_2590 TAIL.$220.met1 TAIL.$222.met1 0.0298913043478
Rext_2591 TAIL.$220.met1 TAIL.$334.met2 4.5
Rext_2592 TAIL.$222.met1 TAIL.$223.met1 0.195652173913
Rext_2593 TAIL.$223.met1 TAIL.$224.met1 0.195652173913
Rext_2594 TAIL.$223.met1 TAIL.$4.li1 9.3
Rext_2595 TAIL.$224.met1 TAIL.$225.met1 0.195652173913
Rext_2596 TAIL.$224.met1 TAIL.$6.li1 9.3
Rext_2597 TAIL.$225.met1 TAIL.$226.met1 0.195652173913
Rext_2598 TAIL.$225.met1 TAIL.$8.li1 9.3
Rext_2599 TAIL.$226.met1 TAIL.$227.met1 0.195652173913
Rext_2600 TAIL.$227.met1 TAIL.$228.met1 0.195652173913
Rext_2601 TAIL.$228.met1 TAIL.$229.met1 0.195652173913
Rext_2602 TAIL.$229.met1 TAIL.$230.met1 0.195652173913
Rext_2603 TAIL.$230.met1 TAIL.$231.met1 0.195652173913
Rext_2604 TAIL.$231.met1 TAIL.$232.met1 0.195652173913
Rext_2605 TAIL.$232.met1 TAIL.$233.met1 0.195652173913
Rext_2606 TAIL.$233.met1 TAIL.$234.met1 0.195652173913
Rext_2607 TAIL.$233.met1 TAIL.$24.li1 9.3
Rext_2608 TAIL.$234.met1 TAIL.$235.met1 0.195652173913
Rext_2609 TAIL.$234.met1 TAIL.$26.li1 9.3
Rext_2610 TAIL.$235.met1 TAIL.$236.met1 0.195652173913
Rext_2611 TAIL.$235.met1 TAIL.$28.li1 9.3
Rext_2612 TAIL.$236.met1 TAIL.$237.met1 0.195652173913
Rext_2613 TAIL.$236.met1 TAIL.$30.li1 9.3
Rext_2614 TAIL.$237.met1 TAIL.$238.met1 0.195652173913
Rext_2615 TAIL.$237.met1 TAIL.$32.li1 9.3
Rext_2616 TAIL.$238.met1 TAIL.$239.met1 0.195652173913
Rext_2617 TAIL.$238.met1 TAIL.$34.li1 9.3
Rext_2618 TAIL.$239.met1 TAIL.$240.met1 0.195652173913
Rext_2619 TAIL.$239.met1 TAIL.$36.li1 9.3
Rext_2620 TAIL.$24.li1 TAIL.$26.li1 27.1058823529
Rext_2621 TAIL.$24.li1 TAIL.P1.nsdm 185
Rext_2622 TAIL.$240.met1 TAIL.$241.met1 0.195652173913
Rext_2623 TAIL.$240.met1 TAIL.$38.li1 9.3
Rext_2624 TAIL.$241.met1 TAIL.$242.met1 0.195652173913
Rext_2625 TAIL.$241.met1 TAIL.$40.li1 9.3
Rext_2626 TAIL.$242.met1 TAIL.$243.met1 0.195652173913
Rext_2627 TAIL.$242.met1 TAIL.$42.li1 9.3
Rext_2628 TAIL.$243.met1 TAIL.$244.met1 0.195652173913
Rext_2629 TAIL.$243.met1 TAIL.$44.li1 9.3
Rext_2630 TAIL.$244.met1 TAIL.$245.met1 0.195652173913
Rext_2631 TAIL.$244.met1 TAIL.$46.li1 9.3
Rext_2632 TAIL.$245.met1 TAIL.$246.met1 0.195652173913
Rext_2633 TAIL.$245.met1 TAIL.$48.li1 9.3
Rext_2634 TAIL.$246.met1 TAIL.$247.met1 0.195652173913
Rext_2635 TAIL.$246.met1 TAIL.$50.li1 9.3
Rext_2636 TAIL.$247.met1 TAIL.$248.met1 0.195652173913
Rext_2637 TAIL.$247.met1 TAIL.$52.li1 9.3
Rext_2638 TAIL.$248.met1 TAIL.$249.met1 0.195652173913
Rext_2639 TAIL.$248.met1 TAIL.$54.li1 9.3
Rext_2640 TAIL.$249.met1 TAIL.$250.met1 0.195652173913
Rext_2641 TAIL.$249.met1 TAIL.$56.li1 9.3
Rext_2642 TAIL.$250.met1 TAIL.$251.met1 0.195652173913
Rext_2643 TAIL.$250.met1 TAIL.$58.li1 9.3
Rext_2644 TAIL.$251.met1 TAIL.$252.met1 0.195652173913
Rext_2645 TAIL.$251.met1 TAIL.$60.li1 9.3
Rext_2646 TAIL.$252.met1 TAIL.$253.met1 0.195652173913
Rext_2647 TAIL.$252.met1 TAIL.$62.li1 9.3
Rext_2648 TAIL.$253.met1 TAIL.$254.met1 0.195652173913
Rext_2649 TAIL.$253.met1 TAIL.$64.li1 9.3
Rext_2650 TAIL.$254.met1 TAIL.$255.met1 0.195652173913
Rext_2651 TAIL.$254.met1 TAIL.$66.li1 9.3
Rext_2652 TAIL.$255.met1 TAIL.$256.met1 0.195652173913
Rext_2653 TAIL.$255.met1 TAIL.$68.li1 9.3
Rext_2654 TAIL.$256.met1 TAIL.$257.met1 0.195652173913
Rext_2655 TAIL.$256.met1 TAIL.$70.li1 9.3
Rext_2656 TAIL.$257.met1 TAIL.$258.met1 0.195652173913
Rext_2657 TAIL.$257.met1 TAIL.$72.li1 9.3
Rext_2658 TAIL.$258.met1 TAIL.$259.met1 0.195652173913
Rext_2659 TAIL.$258.met1 TAIL.$74.li1 9.3
Rext_2660 TAIL.$259.met1 TAIL.$260.met1 0.195652173913
Rext_2661 TAIL.$259.met1 TAIL.$76.li1 9.3
Rext_2662 TAIL.$26.li1 TAIL.$28.li1 27.1058823529
Rext_2663 TAIL.$26.li1 TAIL.P1.nsdm 185
Rext_2664 TAIL.$260.met1 TAIL.$261.met1 0.195652173913
Rext_2665 TAIL.$260.met1 TAIL.$78.li1 9.3
Rext_2666 TAIL.$261.met1 TAIL.$262.met1 0.195652173913
Rext_2667 TAIL.$261.met1 TAIL.$80.li1 9.3
Rext_2668 TAIL.$262.met1 TAIL.$263.met1 0.195652173913
Rext_2669 TAIL.$262.met1 TAIL.$82.li1 9.3
Rext_2670 TAIL.$263.met1 TAIL.$264.met1 0.195652173913
Rext_2671 TAIL.$263.met1 TAIL.$84.li1 9.3
Rext_2672 TAIL.$264.met1 TAIL.$86.li1 9.3
Rext_2673 TAIL.$265.met1 TAIL.$309.met1 0.165760869565
Rext_2674 TAIL.$265.met1 TAIL.$88.li1 9.3
Rext_2675 TAIL.$266.met1 TAIL.$267.met1 0.195652173913
Rext_2676 TAIL.$266.met1 TAIL.$309.met1 0.0298913043478
Rext_2677 TAIL.$266.met1 TAIL.$90.li1 9.3
Rext_2678 TAIL.$267.met1 TAIL.$268.met1 0.195652173913
Rext_2679 TAIL.$267.met1 TAIL.$92.li1 9.3
Rext_2680 TAIL.$268.met1 TAIL.$269.met1 0.195652173913
Rext_2681 TAIL.$268.met1 TAIL.$94.li1 9.3
Rext_2682 TAIL.$269.met1 TAIL.$270.met1 0.195652173913
Rext_2683 TAIL.$269.met1 TAIL.$96.li1 9.3
Rext_2684 TAIL.$270.met1 TAIL.$271.met1 0.195652173913
Rext_2685 TAIL.$270.met1 TAIL.$98.li1 9.3
Rext_2686 TAIL.$271.met1 TAIL.$272.met1 0.195652173913
Rext_2687 TAIL.$272.met1 TAIL.$273.met1 0.195652173913
Rext_2688 TAIL.$273.met1 TAIL.$274.met1 0.195652173913
Rext_2689 TAIL.$274.met1 TAIL.$275.met1 0.195652173913
Rext_2690 TAIL.$275.met1 TAIL.$276.met1 0.195652173913
Rext_2691 TAIL.$276.met1 TAIL.$277.met1 0.195652173913
Rext_2692 TAIL.$277.met1 TAIL.$278.met1 0.195652173913
Rext_2693 TAIL.$278.met1 TAIL.$279.met1 0.195652173913
Rext_2694 TAIL.$279.met1 TAIL.$280.met1 0.195652173913
Rext_2695 TAIL.$28.li1 TAIL.$30.li1 27.1058823529
Rext_2696 TAIL.$28.li1 TAIL.P1.nsdm 185
Rext_2697 TAIL.$280.met1 TAIL.$281.met1 0.195652173913
Rext_2698 TAIL.$281.met1 TAIL.$282.met1 0.195652173913
Rext_2699 TAIL.$282.met1 TAIL.$283.met1 0.195652173913
Rext_2700 TAIL.$283.met1 TAIL.$284.met1 0.195652173913
Rext_2701 TAIL.$284.met1 TAIL.$285.met1 0.195652173913
Rext_2702 TAIL.$285.met1 TAIL.$286.met1 0.195652173913
Rext_2703 TAIL.$286.met1 TAIL.$287.met1 0.195652173913
Rext_2704 TAIL.$287.met1 TAIL.$288.met1 0.195652173913
Rext_2705 TAIL.$288.met1 TAIL.$289.met1 0.195652173913
Rext_2706 TAIL.$289.met1 TAIL.$290.met1 0.195652173913
Rext_2707 TAIL.$290.met1 TAIL.$291.met1 0.195652173913
Rext_2708 TAIL.$291.met1 TAIL.$292.met1 0.195652173913
Rext_2709 TAIL.$292.met1 TAIL.$293.met1 0.195652173913
Rext_2710 TAIL.$293.met1 TAIL.$294.met1 0.195652173913
Rext_2711 TAIL.$294.met1 TAIL.$295.met1 0.195652173913
Rext_2712 TAIL.$295.met1 TAIL.$296.met1 0.195652173913
Rext_2713 TAIL.$296.met1 TAIL.$297.met1 0.195652173913
Rext_2714 TAIL.$297.met1 TAIL.$298.met1 0.195652173913
Rext_2715 TAIL.$298.met1 TAIL.$299.met1 0.195652173913
Rext_2716 TAIL.$299.met1 TAIL.$300.met1 0.195652173913
Rext_2717 TAIL.$30.li1 TAIL.$32.li1 27.1058823529
Rext_2718 TAIL.$30.li1 TAIL.P1.nsdm 185
Rext_2719 TAIL.$300.met1 TAIL.$301.met1 0.195652173913
Rext_2720 TAIL.$301.met1 TAIL.$302.met1 0.195652173913
Rext_2721 TAIL.$302.met1 TAIL.$303.met1 0.195652173913
Rext_2722 TAIL.$303.met1 TAIL.$304.met1 0.195652173913
Rext_2723 TAIL.$304.met1 TAIL.$305.met1 0.195652173913
Rext_2724 TAIL.$305.met1 TAIL.$306.met1 0.195652173913
Rext_2725 TAIL.$306.met1 TAIL.$307.met1 0.195652173913
Rext_2726 TAIL.$307.met1 TAIL.$308.met1 0.195652173913
Rext_2727 TAIL.$309.met1 TAIL.$335.met2 4.5
Rext_2728 TAIL.$310.met1 TAIL.$311.met1 0.192934782609
Rext_2729 TAIL.$310.met1 TAIL.$312.met1 0.00271739130435
Rext_2730 TAIL.$310.met1 TAIL.$338.met2 4.5
Rext_2731 TAIL.$312.met1 TAIL.$313.met1 0.195652173913
Rext_2732 TAIL.$313.met1 TAIL.$314.met1 0.195652173913
Rext_2733 TAIL.$314.met1 TAIL.$315.met1 0.195652173913
Rext_2734 TAIL.$315.met1 TAIL.$316.met1 0.195652173913
Rext_2735 TAIL.$316.met1 TAIL.$317.met1 0.195652173913
Rext_2736 TAIL.$317.met1 TAIL.$318.met1 0.195652173913
Rext_2737 TAIL.$318.met1 TAIL.$319.met1 0.195652173913
Rext_2738 TAIL.$319.met1 TAIL.$320.met1 0.195652173913
Rext_2739 TAIL.$32.li1 TAIL.$34.li1 27.1058823529
Rext_2740 TAIL.$32.li1 TAIL.P1.nsdm 185
Rext_2741 TAIL.$320.met1 TAIL.$321.met1 0.195652173913
Rext_2742 TAIL.$321.met1 TAIL.$322.met1 0.195652173913
Rext_2743 TAIL.$322.met1 TAIL.$323.met1 0.195652173913
Rext_2744 TAIL.$323.met1 TAIL.$324.met1 0.195652173913
Rext_2745 TAIL.$324.met1 TAIL.$325.met1 0.195652173913
Rext_2746 TAIL.$325.met1 TAIL.$326.met1 0.195652173913
Rext_2747 TAIL.$326.met1 TAIL.$327.met1 0.195652173913
Rext_2748 TAIL.$327.met1 TAIL.$328.met1 0.195652173913
Rext_2749 TAIL.$328.met1 TAIL.$329.met1 0.195652173913
Rext_2750 TAIL.$329.met1 TAIL.$330.met1 0.195652173913
Rext_2751 TAIL.$330.met1 TAIL.$331.met1 0.195652173913
Rext_2752 TAIL.$331.met1 TAIL.$332.met1 0.195652173913
Rext_2753 TAIL.$333.met2 TAIL.$334.met2 0.0493827160494
Rext_2754 TAIL.$333.met2 TAIL.$339.met3 3.41
Rext_2755 TAIL.$335.met2 TAIL.$336.met2 0.104938271605
Rext_2756 TAIL.$336.met2 TAIL.$340.met3 3.41
Rext_2757 TAIL.$339.met3 TAIL.$340.met3 0.846
Rext_2758 TAIL.$34.li1 TAIL.$36.li1 27.1058823529
Rext_2759 TAIL.$34.li1 TAIL.P1.nsdm 185
Rext_2760 TAIL.$340.met3 TAIL.$341.met3 1.16325
Rext_2761 TAIL.$36.li1 TAIL.$38.li1 27.1058823529
Rext_2762 TAIL.$36.li1 TAIL.P1.nsdm 185
Rext_2763 TAIL.$38.li1 TAIL.$40.li1 27.1058823529
Rext_2764 TAIL.$38.li1 TAIL.P1.nsdm 185
Rext_2765 TAIL.$4.li1 TAIL.$6.li1 27.1058823529
Rext_2766 TAIL.$4.li1 TAIL.P1.nsdm 185
Rext_2767 TAIL.$40.li1 TAIL.$42.li1 27.1058823529
Rext_2768 TAIL.$40.li1 TAIL.P1.nsdm 185
Rext_2769 TAIL.$42.li1 TAIL.$44.li1 27.1058823529
Rext_2770 TAIL.$42.li1 TAIL.P1.nsdm 185
Rext_2771 TAIL.$44.li1 TAIL.$46.li1 27.1058823529
Rext_2772 TAIL.$44.li1 TAIL.P1.nsdm 185
Rext_2773 TAIL.$46.li1 TAIL.$48.li1 27.1058823529
Rext_2774 TAIL.$46.li1 TAIL.P1.nsdm 185
Rext_2775 TAIL.$48.li1 TAIL.$50.li1 27.1058823529
Rext_2776 TAIL.$48.li1 TAIL.P1.nsdm 185
Rext_2777 TAIL.$50.li1 TAIL.$52.li1 27.1058823529
Rext_2778 TAIL.$50.li1 TAIL.P1.nsdm 185
Rext_2779 TAIL.$52.li1 TAIL.$54.li1 27.1058823529
Rext_2780 TAIL.$52.li1 TAIL.P1.nsdm 185
Rext_2781 TAIL.$54.li1 TAIL.$56.li1 27.1058823529
Rext_2782 TAIL.$54.li1 TAIL.P1.nsdm 185
Rext_2783 TAIL.$56.li1 TAIL.$58.li1 27.1058823529
Rext_2784 TAIL.$56.li1 TAIL.P1.nsdm 185
Rext_2785 TAIL.$58.li1 TAIL.$60.li1 27.1058823529
Rext_2786 TAIL.$58.li1 TAIL.P1.nsdm 185
Rext_2787 TAIL.$6.li1 TAIL.$8.li1 27.1058823529
Rext_2788 TAIL.$6.li1 TAIL.P1.nsdm 185
Rext_2789 TAIL.$60.li1 TAIL.$62.li1 27.1058823529
Rext_2790 TAIL.$60.li1 TAIL.P1.nsdm 185
Rext_2791 TAIL.$62.li1 TAIL.$64.li1 27.1058823529
Rext_2792 TAIL.$62.li1 TAIL.P1.nsdm 185
Rext_2793 TAIL.$64.li1 TAIL.$66.li1 27.1058823529
Rext_2794 TAIL.$64.li1 TAIL.P1.nsdm 185
Rext_2795 TAIL.$66.li1 TAIL.$68.li1 27.1058823529
Rext_2796 TAIL.$66.li1 TAIL.P1.nsdm 185
Rext_2797 TAIL.$68.li1 TAIL.$70.li1 27.1058823529
Rext_2798 TAIL.$68.li1 TAIL.P1.nsdm 185
Rext_2799 TAIL.$70.li1 TAIL.$72.li1 27.1058823529
Rext_2800 TAIL.$70.li1 TAIL.P1.nsdm 185
Rext_2801 TAIL.$72.li1 TAIL.$74.li1 27.1058823529
Rext_2802 TAIL.$72.li1 TAIL.P1.nsdm 185
Rext_2803 TAIL.$74.li1 TAIL.$76.li1 27.1058823529
Rext_2804 TAIL.$74.li1 TAIL.P1.nsdm 185
Rext_2805 TAIL.$76.li1 TAIL.$78.li1 27.1058823529
Rext_2806 TAIL.$76.li1 TAIL.P1.nsdm 185
Rext_2807 TAIL.$78.li1 TAIL.$80.li1 27.1058823529
Rext_2808 TAIL.$78.li1 TAIL.P1.nsdm 185
Rext_2809 TAIL.$8.li1 TAIL.P1.nsdm 185
Rext_2810 TAIL.$80.li1 TAIL.$82.li1 27.1058823529
Rext_2811 TAIL.$80.li1 TAIL.P1.nsdm 185
Rext_2812 TAIL.$82.li1 TAIL.$84.li1 27.1058823529
Rext_2813 TAIL.$82.li1 TAIL.P1.nsdm 185
Rext_2814 TAIL.$84.li1 TAIL.$86.li1 27.1058823529
Rext_2815 TAIL.$84.li1 TAIL.P1.nsdm 185
Rext_2816 TAIL.$86.li1 TAIL.P1.nsdm 185
Rext_2817 TAIL.$88.li1 TAIL.$90.li1 27.1058823529
Rext_2818 TAIL.$88.li1 TAIL.P2.nsdm 185
Rext_2819 TAIL.$90.li1 TAIL.$92.li1 27.1058823529
Rext_2820 TAIL.$90.li1 TAIL.P2.nsdm 185
Rext_2821 TAIL.$92.li1 TAIL.$94.li1 27.1058823529
Rext_2822 TAIL.$92.li1 TAIL.P2.nsdm 185
Rext_2823 TAIL.$94.li1 TAIL.$96.li1 27.1058823529
Rext_2824 TAIL.$94.li1 TAIL.P2.nsdm 185
Rext_2825 TAIL.$96.li1 TAIL.$98.li1 27.1058823529
Rext_2826 TAIL.$96.li1 TAIL.P2.nsdm 185
Rext_2827 TAIL.$98.li1 TAIL.P2.nsdm 185
Rext_2828 VDD VDD.$658.met4 0.0168948990968
Rext_2829 VDD VDD.$659.met4 0.0142287081598
Rext_2830 VDD.$0.li1 VDD.$2.li1 27.1058823529
Rext_2831 VDD.$0.li1 VDD.$345.met1 9.3
Rext_2832 VDD.$0.li1 VDD.P3.psdm 585
Rext_2833 VDD.$10.li1 VDD.$12.li1 27.1058823529
Rext_2834 VDD.$10.li1 VDD.$350.met1 9.3
Rext_2835 VDD.$10.li1 VDD.$8.li1 27.1058823529
Rext_2836 VDD.$10.li1 VDD.P3.psdm 585
Rext_2837 VDD.$100.li1 VDD.$102.li1 27.1058823529
Rext_2838 VDD.$100.li1 VDD.$386.met1 9.3
Rext_2839 VDD.$100.li1 VDD.$98.li1 27.1058823529
Rext_2840 VDD.$100.li1 VDD.P6.psdm 585
Rext_2841 VDD.$102.li1 VDD.$104.li1 27.1058823529
Rext_2842 VDD.$102.li1 VDD.$387.met1 9.3
Rext_2843 VDD.$102.li1 VDD.P6.psdm 585
Rext_2844 VDD.$104.li1 VDD.$106.li1 27.1058823529
Rext_2845 VDD.$104.li1 VDD.$388.met1 9.3
Rext_2846 VDD.$104.li1 VDD.P6.psdm 585
Rext_2847 VDD.$106.li1 VDD.$108.li1 27.1058823529
Rext_2848 VDD.$106.li1 VDD.$389.met1 9.3
Rext_2849 VDD.$106.li1 VDD.P6.psdm 585
Rext_2850 VDD.$108.li1 VDD.$110.li1 27.1058823529
Rext_2851 VDD.$108.li1 VDD.$390.met1 9.3
Rext_2852 VDD.$108.li1 VDD.P6.psdm 585
Rext_2853 VDD.$110.li1 VDD.$391.met1 9.3
Rext_2854 VDD.$110.li1 VDD.P6.psdm 585
Rext_2855 VDD.$112.li1 VDD.$113.li1 27.1058823529
Rext_2856 VDD.$112.li1 VDD.$684.nwell 185
Rext_2857 VDD.$113.li1 VDD.$114.li1 27.1058823529
Rext_2858 VDD.$113.li1 VDD.$685.nwell 185
Rext_2859 VDD.$114.li1 VDD.$115.li1 27.1058823529
Rext_2860 VDD.$114.li1 VDD.$686.nwell 185
Rext_2861 VDD.$115.li1 VDD.$116.li1 27.1058823529
Rext_2862 VDD.$115.li1 VDD.$687.nwell 185
Rext_2863 VDD.$116.li1 VDD.$117.li1 27.1058823529
Rext_2864 VDD.$116.li1 VDD.$688.nwell 185
Rext_2865 VDD.$117.li1 VDD.$118.li1 27.1058823529
Rext_2866 VDD.$117.li1 VDD.$689.nwell 185
Rext_2867 VDD.$118.li1 VDD.$119.li1 27.1058823529
Rext_2868 VDD.$118.li1 VDD.$690.nwell 185
Rext_2869 VDD.$119.li1 VDD.$120.li1 27.1058823529
Rext_2870 VDD.$119.li1 VDD.$691.nwell 185
Rext_2871 VDD.$12.li1 VDD.$14.li1 27.1058823529
Rext_2872 VDD.$12.li1 VDD.$351.met1 9.3
Rext_2873 VDD.$12.li1 VDD.P3.psdm 585
Rext_2874 VDD.$120.li1 VDD.$121.li1 27.1058823529
Rext_2875 VDD.$120.li1 VDD.$692.nwell 185
Rext_2876 VDD.$121.li1 VDD.$122.li1 27.1058823529
Rext_2877 VDD.$121.li1 VDD.$693.nwell 185
Rext_2878 VDD.$122.li1 VDD.$134.li1 13.5529411765
Rext_2879 VDD.$122.li1 VDD.$694.nwell 185
Rext_2880 VDD.$123.li1 VDD.$124.li1 27.1058823529
Rext_2881 VDD.$123.li1 VDD.$134.li1 13.5529411765
Rext_2882 VDD.$123.li1 VDD.$695.nwell 185
Rext_2883 VDD.$124.li1 VDD.$125.li1 27.1058823529
Rext_2884 VDD.$124.li1 VDD.$696.nwell 185
Rext_2885 VDD.$125.li1 VDD.$126.li1 27.1058823529
Rext_2886 VDD.$125.li1 VDD.$697.nwell 185
Rext_2887 VDD.$126.li1 VDD.$127.li1 27.1058823529
Rext_2888 VDD.$126.li1 VDD.$698.nwell 185
Rext_2889 VDD.$127.li1 VDD.$128.li1 27.1058823529
Rext_2890 VDD.$127.li1 VDD.$699.nwell 185
Rext_2891 VDD.$128.li1 VDD.$129.li1 27.1058823529
Rext_2892 VDD.$128.li1 VDD.$700.nwell 185
Rext_2893 VDD.$129.li1 VDD.$130.li1 27.1058823529
Rext_2894 VDD.$129.li1 VDD.$701.nwell 185
Rext_2895 VDD.$130.li1 VDD.$131.li1 27.1058823529
Rext_2896 VDD.$130.li1 VDD.$702.nwell 185
Rext_2897 VDD.$131.li1 VDD.$132.li1 27.1058823529
Rext_2898 VDD.$131.li1 VDD.$703.nwell 185
Rext_2899 VDD.$132.li1 VDD.$133.li1 27.1058823529
Rext_2900 VDD.$132.li1 VDD.$704.nwell 185
Rext_2901 VDD.$133.li1 VDD.$705.nwell 185
Rext_2902 VDD.$134.li1 VDD.$135.li1 20.0827586207
Rext_2903 VDD.$135.li1 VDD.$392.met1 9.3
Rext_2904 VDD.$136.li1 VDD.$138.li1 27.1058823529
Rext_2905 VDD.$136.li1 VDD.$394.met1 9.3
Rext_2906 VDD.$136.li1 VDD.P5.psdm 585
Rext_2907 VDD.$138.li1 VDD.$140.li1 27.1058823529
Rext_2908 VDD.$138.li1 VDD.$395.met1 9.3
Rext_2909 VDD.$138.li1 VDD.P5.psdm 585
Rext_2910 VDD.$14.li1 VDD.$16.li1 27.1058823529
Rext_2911 VDD.$14.li1 VDD.$352.met1 9.3
Rext_2912 VDD.$14.li1 VDD.P3.psdm 585
Rext_2913 VDD.$140.li1 VDD.$142.li1 27.1058823529
Rext_2914 VDD.$140.li1 VDD.$396.met1 9.3
Rext_2915 VDD.$140.li1 VDD.P5.psdm 585
Rext_2916 VDD.$142.li1 VDD.$144.li1 27.1058823529
Rext_2917 VDD.$142.li1 VDD.$397.met1 9.3
Rext_2918 VDD.$142.li1 VDD.P5.psdm 585
Rext_2919 VDD.$144.li1 VDD.$146.li1 27.1058823529
Rext_2920 VDD.$144.li1 VDD.$398.met1 9.3
Rext_2921 VDD.$144.li1 VDD.P5.psdm 585
Rext_2922 VDD.$146.li1 VDD.$148.li1 27.1058823529
Rext_2923 VDD.$146.li1 VDD.$399.met1 9.3
Rext_2924 VDD.$146.li1 VDD.P5.psdm 585
Rext_2925 VDD.$148.li1 VDD.$150.li1 27.1058823529
Rext_2926 VDD.$148.li1 VDD.$400.met1 9.3
Rext_2927 VDD.$148.li1 VDD.P5.psdm 585
Rext_2928 VDD.$150.li1 VDD.$152.li1 27.1058823529
Rext_2929 VDD.$150.li1 VDD.$401.met1 9.3
Rext_2930 VDD.$150.li1 VDD.P5.psdm 585
Rext_2931 VDD.$152.li1 VDD.$154.li1 27.1058823529
Rext_2932 VDD.$152.li1 VDD.$402.met1 9.3
Rext_2933 VDD.$152.li1 VDD.P5.psdm 585
Rext_2934 VDD.$154.li1 VDD.$156.li1 27.1058823529
Rext_2935 VDD.$154.li1 VDD.$403.met1 9.3
Rext_2936 VDD.$154.li1 VDD.P5.psdm 585
Rext_2937 VDD.$156.li1 VDD.$158.li1 27.1058823529
Rext_2938 VDD.$156.li1 VDD.$404.met1 9.3
Rext_2939 VDD.$156.li1 VDD.P5.psdm 585
Rext_2940 VDD.$158.li1 VDD.$160.li1 27.1058823529
Rext_2941 VDD.$158.li1 VDD.$405.met1 9.3
Rext_2942 VDD.$158.li1 VDD.P5.psdm 585
Rext_2943 VDD.$16.li1 VDD.$18.li1 27.1058823529
Rext_2944 VDD.$16.li1 VDD.$353.met1 9.3
Rext_2945 VDD.$16.li1 VDD.P3.psdm 585
Rext_2946 VDD.$160.li1 VDD.$162.li1 27.1058823529
Rext_2947 VDD.$160.li1 VDD.$406.met1 9.3
Rext_2948 VDD.$160.li1 VDD.P5.psdm 585
Rext_2949 VDD.$162.li1 VDD.$164.li1 27.1058823529
Rext_2950 VDD.$162.li1 VDD.$407.met1 9.3
Rext_2951 VDD.$162.li1 VDD.P5.psdm 585
Rext_2952 VDD.$164.li1 VDD.$166.li1 27.1058823529
Rext_2953 VDD.$164.li1 VDD.$408.met1 9.3
Rext_2954 VDD.$164.li1 VDD.P5.psdm 585
Rext_2955 VDD.$166.li1 VDD.$168.li1 27.1058823529
Rext_2956 VDD.$166.li1 VDD.$409.met1 9.3
Rext_2957 VDD.$166.li1 VDD.P5.psdm 585
Rext_2958 VDD.$168.li1 VDD.$170.li1 27.1058823529
Rext_2959 VDD.$168.li1 VDD.$410.met1 9.3
Rext_2960 VDD.$168.li1 VDD.P5.psdm 585
Rext_2961 VDD.$170.li1 VDD.$172.li1 27.1058823529
Rext_2962 VDD.$170.li1 VDD.$411.met1 9.3
Rext_2963 VDD.$170.li1 VDD.P5.psdm 585
Rext_2964 VDD.$172.li1 VDD.$174.li1 27.1058823529
Rext_2965 VDD.$172.li1 VDD.$412.met1 9.3
Rext_2966 VDD.$172.li1 VDD.P5.psdm 585
Rext_2967 VDD.$174.li1 VDD.$176.li1 27.1058823529
Rext_2968 VDD.$174.li1 VDD.$413.met1 9.3
Rext_2969 VDD.$174.li1 VDD.P5.psdm 585
Rext_2970 VDD.$176.li1 VDD.$178.li1 27.1058823529
Rext_2971 VDD.$176.li1 VDD.$414.met1 9.3
Rext_2972 VDD.$176.li1 VDD.P5.psdm 585
Rext_2973 VDD.$178.li1 VDD.$415.met1 9.3
Rext_2974 VDD.$178.li1 VDD.P5.psdm 585
Rext_2975 VDD.$18.li1 VDD.$20.li1 27.1058823529
Rext_2976 VDD.$18.li1 VDD.$354.met1 9.3
Rext_2977 VDD.$18.li1 VDD.P3.psdm 585
Rext_2978 VDD.$180.li1 VDD.$181.li1 27.1058823529
Rext_2979 VDD.$180.li1 VDD.$706.nwell 185
Rext_2980 VDD.$181.li1 VDD.$182.li1 27.1058823529
Rext_2981 VDD.$181.li1 VDD.$707.nwell 185
Rext_2982 VDD.$182.li1 VDD.$183.li1 27.1058823529
Rext_2983 VDD.$182.li1 VDD.$708.nwell 185
Rext_2984 VDD.$183.li1 VDD.$184.li1 27.1058823529
Rext_2985 VDD.$183.li1 VDD.$709.nwell 185
Rext_2986 VDD.$184.li1 VDD.$185.li1 27.1058823529
Rext_2987 VDD.$184.li1 VDD.$710.nwell 185
Rext_2988 VDD.$185.li1 VDD.$186.li1 27.1058823529
Rext_2989 VDD.$185.li1 VDD.$711.nwell 185
Rext_2990 VDD.$186.li1 VDD.$187.li1 27.1058823529
Rext_2991 VDD.$186.li1 VDD.$712.nwell 185
Rext_2992 VDD.$187.li1 VDD.$188.li1 27.1058823529
Rext_2993 VDD.$187.li1 VDD.$713.nwell 185
Rext_2994 VDD.$188.li1 VDD.$189.li1 27.1058823529
Rext_2995 VDD.$188.li1 VDD.$714.nwell 185
Rext_2996 VDD.$189.li1 VDD.$190.li1 27.1058823529
Rext_2997 VDD.$189.li1 VDD.$715.nwell 185
Rext_2998 VDD.$190.li1 VDD.$202.li1 13.5529411765
Rext_2999 VDD.$190.li1 VDD.$716.nwell 185
Rext_3000 VDD.$191.li1 VDD.$192.li1 27.1058823529
Rext_3001 VDD.$191.li1 VDD.$202.li1 13.5529411765
Rext_3002 VDD.$191.li1 VDD.$717.nwell 185
Rext_3003 VDD.$192.li1 VDD.$193.li1 27.1058823529
Rext_3004 VDD.$192.li1 VDD.$718.nwell 185
Rext_3005 VDD.$193.li1 VDD.$194.li1 27.1058823529
Rext_3006 VDD.$193.li1 VDD.$719.nwell 185
Rext_3007 VDD.$194.li1 VDD.$195.li1 27.1058823529
Rext_3008 VDD.$194.li1 VDD.$720.nwell 185
Rext_3009 VDD.$195.li1 VDD.$196.li1 27.1058823529
Rext_3010 VDD.$195.li1 VDD.$721.nwell 185
Rext_3011 VDD.$196.li1 VDD.$197.li1 27.1058823529
Rext_3012 VDD.$196.li1 VDD.$722.nwell 185
Rext_3013 VDD.$197.li1 VDD.$198.li1 27.1058823529
Rext_3014 VDD.$197.li1 VDD.$723.nwell 185
Rext_3015 VDD.$198.li1 VDD.$199.li1 27.1058823529
Rext_3016 VDD.$198.li1 VDD.$724.nwell 185
Rext_3017 VDD.$199.li1 VDD.$200.li1 27.1058823529
Rext_3018 VDD.$199.li1 VDD.$725.nwell 185
Rext_3019 VDD.$2.li1 VDD.$346.met1 9.3
Rext_3020 VDD.$2.li1 VDD.$4.li1 27.1058823529
Rext_3021 VDD.$2.li1 VDD.P3.psdm 585
Rext_3022 VDD.$20.li1 VDD.$22.li1 27.1058823529
Rext_3023 VDD.$20.li1 VDD.$355.met1 9.3
Rext_3024 VDD.$20.li1 VDD.P3.psdm 585
Rext_3025 VDD.$200.li1 VDD.$201.li1 27.1058823529
Rext_3026 VDD.$200.li1 VDD.$726.nwell 185
Rext_3027 VDD.$201.li1 VDD.$727.nwell 185
Rext_3028 VDD.$202.li1 VDD.$203.li1 20.0827586207
Rext_3029 VDD.$203.li1 VDD.$417.met1 9.3
Rext_3030 VDD.$204.li1 VDD.$206.li1 27.1058823529
Rext_3031 VDD.$204.li1 VDD.$420.met1 9.3
Rext_3032 VDD.$204.li1 VDD.P4.psdm 585
Rext_3033 VDD.$206.li1 VDD.$208.li1 27.1058823529
Rext_3034 VDD.$206.li1 VDD.$421.met1 9.3
Rext_3035 VDD.$206.li1 VDD.P4.psdm 585
Rext_3036 VDD.$208.li1 VDD.$210.li1 27.1058823529
Rext_3037 VDD.$208.li1 VDD.$422.met1 9.3
Rext_3038 VDD.$208.li1 VDD.P4.psdm 585
Rext_3039 VDD.$210.li1 VDD.$212.li1 27.1058823529
Rext_3040 VDD.$210.li1 VDD.$423.met1 9.3
Rext_3041 VDD.$210.li1 VDD.P4.psdm 585
Rext_3042 VDD.$212.li1 VDD.$214.li1 27.1058823529
Rext_3043 VDD.$212.li1 VDD.$424.met1 9.3
Rext_3044 VDD.$212.li1 VDD.P4.psdm 585
Rext_3045 VDD.$214.li1 VDD.$216.li1 27.1058823529
Rext_3046 VDD.$214.li1 VDD.$425.met1 9.3
Rext_3047 VDD.$214.li1 VDD.P4.psdm 585
Rext_3048 VDD.$216.li1 VDD.$218.li1 27.1058823529
Rext_3049 VDD.$216.li1 VDD.$426.met1 9.3
Rext_3050 VDD.$216.li1 VDD.P4.psdm 585
Rext_3051 VDD.$218.li1 VDD.$220.li1 27.1058823529
Rext_3052 VDD.$218.li1 VDD.$427.met1 9.3
Rext_3053 VDD.$218.li1 VDD.P4.psdm 585
Rext_3054 VDD.$22.li1 VDD.$24.li1 27.1058823529
Rext_3055 VDD.$22.li1 VDD.$356.met1 9.3
Rext_3056 VDD.$22.li1 VDD.P3.psdm 585
Rext_3057 VDD.$220.li1 VDD.$222.li1 27.1058823529
Rext_3058 VDD.$220.li1 VDD.$428.met1 9.3
Rext_3059 VDD.$220.li1 VDD.P4.psdm 585
Rext_3060 VDD.$222.li1 VDD.$224.li1 27.1058823529
Rext_3061 VDD.$222.li1 VDD.$429.met1 9.3
Rext_3062 VDD.$222.li1 VDD.P4.psdm 585
Rext_3063 VDD.$224.li1 VDD.$226.li1 27.1058823529
Rext_3064 VDD.$224.li1 VDD.$430.met1 9.3
Rext_3065 VDD.$224.li1 VDD.P4.psdm 585
Rext_3066 VDD.$226.li1 VDD.$228.li1 27.1058823529
Rext_3067 VDD.$226.li1 VDD.$431.met1 9.3
Rext_3068 VDD.$226.li1 VDD.P4.psdm 585
Rext_3069 VDD.$228.li1 VDD.$230.li1 27.1058823529
Rext_3070 VDD.$228.li1 VDD.$432.met1 9.3
Rext_3071 VDD.$228.li1 VDD.P4.psdm 585
Rext_3072 VDD.$230.li1 VDD.$232.li1 27.1058823529
Rext_3073 VDD.$230.li1 VDD.$433.met1 9.3
Rext_3074 VDD.$230.li1 VDD.P4.psdm 585
Rext_3075 VDD.$232.li1 VDD.$234.li1 27.1058823529
Rext_3076 VDD.$232.li1 VDD.$434.met1 9.3
Rext_3077 VDD.$232.li1 VDD.P4.psdm 585
Rext_3078 VDD.$234.li1 VDD.$236.li1 27.1058823529
Rext_3079 VDD.$234.li1 VDD.$435.met1 9.3
Rext_3080 VDD.$234.li1 VDD.P4.psdm 585
Rext_3081 VDD.$236.li1 VDD.$238.li1 27.1058823529
Rext_3082 VDD.$236.li1 VDD.$436.met1 9.3
Rext_3083 VDD.$236.li1 VDD.P4.psdm 585
Rext_3084 VDD.$238.li1 VDD.$240.li1 27.1058823529
Rext_3085 VDD.$238.li1 VDD.$437.met1 9.3
Rext_3086 VDD.$238.li1 VDD.P4.psdm 585
Rext_3087 VDD.$24.li1 VDD.$26.li1 27.1058823529
Rext_3088 VDD.$24.li1 VDD.$357.met1 9.3
Rext_3089 VDD.$24.li1 VDD.P3.psdm 585
Rext_3090 VDD.$240.li1 VDD.$242.li1 27.1058823529
Rext_3091 VDD.$240.li1 VDD.$438.met1 9.3
Rext_3092 VDD.$240.li1 VDD.P4.psdm 585
Rext_3093 VDD.$242.li1 VDD.$244.li1 27.1058823529
Rext_3094 VDD.$242.li1 VDD.$439.met1 9.3
Rext_3095 VDD.$242.li1 VDD.P4.psdm 585
Rext_3096 VDD.$244.li1 VDD.$246.li1 27.1058823529
Rext_3097 VDD.$244.li1 VDD.$440.met1 9.3
Rext_3098 VDD.$244.li1 VDD.P4.psdm 585
Rext_3099 VDD.$246.li1 VDD.$441.met1 9.3
Rext_3100 VDD.$246.li1 VDD.P4.psdm 585
Rext_3101 VDD.$248.li1 VDD.$249.li1 27.1058823529
Rext_3102 VDD.$248.li1 VDD.$728.nwell 185
Rext_3103 VDD.$249.li1 VDD.$250.li1 27.1058823529
Rext_3104 VDD.$249.li1 VDD.$729.nwell 185
Rext_3105 VDD.$250.li1 VDD.$251.li1 27.1058823529
Rext_3106 VDD.$250.li1 VDD.$730.nwell 185
Rext_3107 VDD.$251.li1 VDD.$252.li1 27.1058823529
Rext_3108 VDD.$251.li1 VDD.$731.nwell 185
Rext_3109 VDD.$252.li1 VDD.$253.li1 27.1058823529
Rext_3110 VDD.$252.li1 VDD.$732.nwell 185
Rext_3111 VDD.$253.li1 VDD.$254.li1 27.1058823529
Rext_3112 VDD.$253.li1 VDD.$733.nwell 185
Rext_3113 VDD.$254.li1 VDD.$255.li1 27.1058823529
Rext_3114 VDD.$254.li1 VDD.$734.nwell 185
Rext_3115 VDD.$255.li1 VDD.$256.li1 27.1058823529
Rext_3116 VDD.$255.li1 VDD.$735.nwell 185
Rext_3117 VDD.$256.li1 VDD.$257.li1 27.1058823529
Rext_3118 VDD.$256.li1 VDD.$736.nwell 185
Rext_3119 VDD.$257.li1 VDD.$258.li1 27.1058823529
Rext_3120 VDD.$257.li1 VDD.$737.nwell 185
Rext_3121 VDD.$258.li1 VDD.$270.li1 13.5529411765
Rext_3122 VDD.$258.li1 VDD.$738.nwell 185
Rext_3123 VDD.$259.li1 VDD.$260.li1 27.1058823529
Rext_3124 VDD.$259.li1 VDD.$270.li1 13.5529411765
Rext_3125 VDD.$259.li1 VDD.$739.nwell 185
Rext_3126 VDD.$26.li1 VDD.$28.li1 27.1058823529
Rext_3127 VDD.$26.li1 VDD.$358.met1 9.3
Rext_3128 VDD.$26.li1 VDD.P3.psdm 585
Rext_3129 VDD.$260.li1 VDD.$261.li1 27.1058823529
Rext_3130 VDD.$260.li1 VDD.$740.nwell 185
Rext_3131 VDD.$261.li1 VDD.$262.li1 27.1058823529
Rext_3132 VDD.$261.li1 VDD.$741.nwell 185
Rext_3133 VDD.$262.li1 VDD.$263.li1 27.1058823529
Rext_3134 VDD.$262.li1 VDD.$742.nwell 185
Rext_3135 VDD.$263.li1 VDD.$264.li1 27.1058823529
Rext_3136 VDD.$263.li1 VDD.$743.nwell 185
Rext_3137 VDD.$264.li1 VDD.$265.li1 27.1058823529
Rext_3138 VDD.$264.li1 VDD.$744.nwell 185
Rext_3139 VDD.$265.li1 VDD.$266.li1 27.1058823529
Rext_3140 VDD.$265.li1 VDD.$745.nwell 185
Rext_3141 VDD.$266.li1 VDD.$267.li1 27.1058823529
Rext_3142 VDD.$266.li1 VDD.$746.nwell 185
Rext_3143 VDD.$267.li1 VDD.$268.li1 27.1058823529
Rext_3144 VDD.$267.li1 VDD.$747.nwell 185
Rext_3145 VDD.$268.li1 VDD.$269.li1 27.1058823529
Rext_3146 VDD.$268.li1 VDD.$748.nwell 185
Rext_3147 VDD.$269.li1 VDD.$749.nwell 185
Rext_3148 VDD.$270.li1 VDD.$271.li1 20.0827586207
Rext_3149 VDD.$271.li1 VDD.$442.met1 9.3
Rext_3150 VDD.$272.li1 VDD.$274.li1 27.1058823529
Rext_3151 VDD.$272.li1 VDD.$444.met1 9.3
Rext_3152 VDD.$272.li1 VDD.P1.psdm 585
Rext_3153 VDD.$274.li1 VDD.$276.li1 27.1058823529
Rext_3154 VDD.$274.li1 VDD.$445.met1 9.3
Rext_3155 VDD.$274.li1 VDD.P1.psdm 585
Rext_3156 VDD.$276.li1 VDD.$278.li1 27.1058823529
Rext_3157 VDD.$276.li1 VDD.$446.met1 9.3
Rext_3158 VDD.$276.li1 VDD.P1.psdm 585
Rext_3159 VDD.$278.li1 VDD.$280.li1 27.1058823529
Rext_3160 VDD.$278.li1 VDD.$447.met1 9.3
Rext_3161 VDD.$278.li1 VDD.P1.psdm 585
Rext_3162 VDD.$28.li1 VDD.$30.li1 27.1058823529
Rext_3163 VDD.$28.li1 VDD.$359.met1 9.3
Rext_3164 VDD.$28.li1 VDD.P3.psdm 585
Rext_3165 VDD.$280.li1 VDD.$282.li1 27.1058823529
Rext_3166 VDD.$280.li1 VDD.$448.met1 9.3
Rext_3167 VDD.$280.li1 VDD.P1.psdm 585
Rext_3168 VDD.$282.li1 VDD.$284.li1 27.1058823529
Rext_3169 VDD.$282.li1 VDD.$449.met1 9.3
Rext_3170 VDD.$282.li1 VDD.P1.psdm 585
Rext_3171 VDD.$284.li1 VDD.$286.li1 27.1058823529
Rext_3172 VDD.$284.li1 VDD.$450.met1 9.3
Rext_3173 VDD.$284.li1 VDD.P1.psdm 585
Rext_3174 VDD.$286.li1 VDD.$288.li1 27.1058823529
Rext_3175 VDD.$286.li1 VDD.$451.met1 9.3
Rext_3176 VDD.$286.li1 VDD.P1.psdm 585
Rext_3177 VDD.$288.li1 VDD.$290.li1 27.1058823529
Rext_3178 VDD.$288.li1 VDD.$452.met1 9.3
Rext_3179 VDD.$288.li1 VDD.P1.psdm 585
Rext_3180 VDD.$290.li1 VDD.$292.li1 27.1058823529
Rext_3181 VDD.$290.li1 VDD.$453.met1 9.3
Rext_3182 VDD.$290.li1 VDD.P1.psdm 585
Rext_3183 VDD.$292.li1 VDD.$454.met1 9.3
Rext_3184 VDD.$292.li1 VDD.P1.psdm 585
Rext_3185 VDD.$294.li1 VDD.$295.li1 27.1058823529
Rext_3186 VDD.$294.li1 VDD.$750.nwell 185
Rext_3187 VDD.$295.li1 VDD.$296.li1 27.1058823529
Rext_3188 VDD.$295.li1 VDD.$750.nwell 185
Rext_3189 VDD.$296.li1 VDD.$297.li1 27.1058823529
Rext_3190 VDD.$296.li1 VDD.$750.nwell 185
Rext_3191 VDD.$297.li1 VDD.$298.li1 27.1058823529
Rext_3192 VDD.$297.li1 VDD.$750.nwell 185
Rext_3193 VDD.$298.li1 VDD.$299.li1 27.1058823529
Rext_3194 VDD.$298.li1 VDD.$750.nwell 185
Rext_3195 VDD.$299.li1 VDD.$300.li1 27.1058823529
Rext_3196 VDD.$299.li1 VDD.$305.li1 20.0827586207
Rext_3197 VDD.$299.li1 VDD.$750.nwell 185
Rext_3198 VDD.$30.li1 VDD.$32.li1 27.1058823529
Rext_3199 VDD.$30.li1 VDD.$360.met1 9.3
Rext_3200 VDD.$30.li1 VDD.P3.psdm 585
Rext_3201 VDD.$300.li1 VDD.$301.li1 27.1058823529
Rext_3202 VDD.$300.li1 VDD.$750.nwell 185
Rext_3203 VDD.$301.li1 VDD.$302.li1 27.1058823529
Rext_3204 VDD.$301.li1 VDD.$750.nwell 185
Rext_3205 VDD.$302.li1 VDD.$303.li1 27.1058823529
Rext_3206 VDD.$302.li1 VDD.$750.nwell 185
Rext_3207 VDD.$303.li1 VDD.$304.li1 27.1058823529
Rext_3208 VDD.$303.li1 VDD.$750.nwell 185
Rext_3209 VDD.$304.li1 VDD.$750.nwell 185
Rext_3210 VDD.$305.li1 VDD.$456.met1 9.3
Rext_3211 VDD.$306.li1 VDD.$308.li1 27.1058823529
Rext_3212 VDD.$306.li1 VDD.$459.met1 9.3
Rext_3213 VDD.$306.li1 VDD.P2.psdm 585
Rext_3214 VDD.$308.li1 VDD.$310.li1 27.1058823529
Rext_3215 VDD.$308.li1 VDD.$460.met1 9.3
Rext_3216 VDD.$308.li1 VDD.P2.psdm 585
Rext_3217 VDD.$310.li1 VDD.$312.li1 27.1058823529
Rext_3218 VDD.$310.li1 VDD.$461.met1 9.3
Rext_3219 VDD.$310.li1 VDD.P2.psdm 585
Rext_3220 VDD.$312.li1 VDD.$314.li1 27.1058823529
Rext_3221 VDD.$312.li1 VDD.$462.met1 9.3
Rext_3222 VDD.$312.li1 VDD.P2.psdm 585
Rext_3223 VDD.$314.li1 VDD.$316.li1 27.1058823529
Rext_3224 VDD.$314.li1 VDD.$463.met1 9.3
Rext_3225 VDD.$314.li1 VDD.P2.psdm 585
Rext_3226 VDD.$316.li1 VDD.$318.li1 27.1058823529
Rext_3227 VDD.$316.li1 VDD.$464.met1 9.3
Rext_3228 VDD.$316.li1 VDD.P2.psdm 585
Rext_3229 VDD.$318.li1 VDD.$320.li1 27.1058823529
Rext_3230 VDD.$318.li1 VDD.$465.met1 9.3
Rext_3231 VDD.$318.li1 VDD.P2.psdm 585
Rext_3232 VDD.$32.li1 VDD.$34.li1 27.1058823529
Rext_3233 VDD.$32.li1 VDD.$361.met1 9.3
Rext_3234 VDD.$32.li1 VDD.P3.psdm 585
Rext_3235 VDD.$320.li1 VDD.$322.li1 27.1058823529
Rext_3236 VDD.$320.li1 VDD.$466.met1 9.3
Rext_3237 VDD.$320.li1 VDD.P2.psdm 585
Rext_3238 VDD.$322.li1 VDD.$324.li1 27.1058823529
Rext_3239 VDD.$322.li1 VDD.$467.met1 9.3
Rext_3240 VDD.$322.li1 VDD.P2.psdm 585
Rext_3241 VDD.$324.li1 VDD.$326.li1 27.1058823529
Rext_3242 VDD.$324.li1 VDD.$468.met1 9.3
Rext_3243 VDD.$324.li1 VDD.P2.psdm 585
Rext_3244 VDD.$326.li1 VDD.$469.met1 9.3
Rext_3245 VDD.$326.li1 VDD.P2.psdm 585
Rext_3246 VDD.$328.li1 VDD.$329.li1 27.1058823529
Rext_3247 VDD.$328.li1 VDD.$761.nwell 185
Rext_3248 VDD.$329.li1 VDD.$330.li1 27.1058823529
Rext_3249 VDD.$329.li1 VDD.$761.nwell 185
Rext_3250 VDD.$330.li1 VDD.$331.li1 27.1058823529
Rext_3251 VDD.$330.li1 VDD.$761.nwell 185
Rext_3252 VDD.$331.li1 VDD.$332.li1 27.1058823529
Rext_3253 VDD.$331.li1 VDD.$761.nwell 185
Rext_3254 VDD.$332.li1 VDD.$333.li1 27.1058823529
Rext_3255 VDD.$332.li1 VDD.$761.nwell 185
Rext_3256 VDD.$333.li1 VDD.$334.li1 27.1058823529
Rext_3257 VDD.$333.li1 VDD.$339.li1 20.0827586207
Rext_3258 VDD.$333.li1 VDD.$761.nwell 185
Rext_3259 VDD.$334.li1 VDD.$335.li1 27.1058823529
Rext_3260 VDD.$334.li1 VDD.$761.nwell 185
Rext_3261 VDD.$335.li1 VDD.$336.li1 27.1058823529
Rext_3262 VDD.$335.li1 VDD.$761.nwell 185
Rext_3263 VDD.$336.li1 VDD.$337.li1 27.1058823529
Rext_3264 VDD.$336.li1 VDD.$761.nwell 185
Rext_3265 VDD.$337.li1 VDD.$338.li1 27.1058823529
Rext_3266 VDD.$337.li1 VDD.$761.nwell 185
Rext_3267 VDD.$338.li1 VDD.$761.nwell 185
Rext_3268 VDD.$339.li1 VDD.$470.met1 9.3
Rext_3269 VDD.$34.li1 VDD.$36.li1 27.1058823529
Rext_3270 VDD.$34.li1 VDD.$362.met1 9.3
Rext_3271 VDD.$34.li1 VDD.P3.psdm 585
Rext_3272 VDD.$340.li1 VDD.$473.met1 9.3
Rext_3273 VDD.$340.li1 VDD.P0.psdm 585
Rext_3274 VDD.$342.li1 VDD.$343.li1 20.0827586207
Rext_3275 VDD.$342.li1 VDD.$772.nwell 185
Rext_3276 VDD.$343.li1 VDD.$474.met1 9.3
Rext_3277 VDD.$344.met1 VDD.$345.met1 0.0298913043478
Rext_3278 VDD.$344.met1 VDD.$346.met1 0.165760869565
Rext_3279 VDD.$344.met1 VDD.$477.met2 4.5
Rext_3280 VDD.$346.met1 VDD.$347.met1 0.195652173913
Rext_3281 VDD.$347.met1 VDD.$348.met1 0.195652173913
Rext_3282 VDD.$347.met1 VDD.$4.li1 9.3
Rext_3283 VDD.$348.met1 VDD.$349.met1 0.195652173913
Rext_3284 VDD.$348.met1 VDD.$6.li1 9.3
Rext_3285 VDD.$349.met1 VDD.$350.met1 0.195652173913
Rext_3286 VDD.$349.met1 VDD.$8.li1 9.3
Rext_3287 VDD.$350.met1 VDD.$351.met1 0.195652173913
Rext_3288 VDD.$351.met1 VDD.$352.met1 0.195652173913
Rext_3289 VDD.$352.met1 VDD.$353.met1 0.195652173913
Rext_3290 VDD.$353.met1 VDD.$354.met1 0.195652173913
Rext_3291 VDD.$354.met1 VDD.$355.met1 0.195652173913
Rext_3292 VDD.$355.met1 VDD.$356.met1 0.195652173913
Rext_3293 VDD.$356.met1 VDD.$357.met1 0.195652173913
Rext_3294 VDD.$357.met1 VDD.$358.met1 0.195652173913
Rext_3295 VDD.$358.met1 VDD.$359.met1 0.195652173913
Rext_3296 VDD.$359.met1 VDD.$360.met1 0.195652173913
Rext_3297 VDD.$36.li1 VDD.$363.met1 9.3
Rext_3298 VDD.$36.li1 VDD.$38.li1 27.1058823529
Rext_3299 VDD.$36.li1 VDD.P3.psdm 585
Rext_3300 VDD.$360.met1 VDD.$361.met1 0.195652173913
Rext_3301 VDD.$361.met1 VDD.$362.met1 0.195652173913
Rext_3302 VDD.$362.met1 VDD.$363.met1 0.195652173913
Rext_3303 VDD.$363.met1 VDD.$364.met1 0.195652173913
Rext_3304 VDD.$364.met1 VDD.$365.met1 0.195652173913
Rext_3305 VDD.$364.met1 VDD.$38.li1 9.3
Rext_3306 VDD.$365.met1 VDD.$366.met1 0.195652173913
Rext_3307 VDD.$365.met1 VDD.$40.li1 9.3
Rext_3308 VDD.$366.met1 VDD.$42.li1 9.3
Rext_3309 VDD.$367.met1 VDD.$478.met2 4.5
Rext_3310 VDD.$367.met1 VDD.$67.li1 9.3
Rext_3311 VDD.$369.met1 VDD.$370.met1 0.0298913043478
Rext_3312 VDD.$369.met1 VDD.$371.met1 0.165760869565
Rext_3313 VDD.$369.met1 VDD.$480.met2 4.5
Rext_3314 VDD.$370.met1 VDD.$68.li1 9.3
Rext_3315 VDD.$371.met1 VDD.$372.met1 0.195652173913
Rext_3316 VDD.$371.met1 VDD.$70.li1 9.3
Rext_3317 VDD.$372.met1 VDD.$373.met1 0.195652173913
Rext_3318 VDD.$372.met1 VDD.$72.li1 9.3
Rext_3319 VDD.$373.met1 VDD.$374.met1 0.195652173913
Rext_3320 VDD.$373.met1 VDD.$74.li1 9.3
Rext_3321 VDD.$374.met1 VDD.$375.met1 0.195652173913
Rext_3322 VDD.$374.met1 VDD.$76.li1 9.3
Rext_3323 VDD.$375.met1 VDD.$376.met1 0.195652173913
Rext_3324 VDD.$375.met1 VDD.$78.li1 9.3
Rext_3325 VDD.$376.met1 VDD.$377.met1 0.195652173913
Rext_3326 VDD.$376.met1 VDD.$80.li1 9.3
Rext_3327 VDD.$377.met1 VDD.$378.met1 0.195652173913
Rext_3328 VDD.$377.met1 VDD.$82.li1 9.3
Rext_3329 VDD.$378.met1 VDD.$379.met1 0.195652173913
Rext_3330 VDD.$378.met1 VDD.$84.li1 9.3
Rext_3331 VDD.$379.met1 VDD.$380.met1 0.195652173913
Rext_3332 VDD.$379.met1 VDD.$86.li1 9.3
Rext_3333 VDD.$38.li1 VDD.$40.li1 27.1058823529
Rext_3334 VDD.$38.li1 VDD.P3.psdm 585
Rext_3335 VDD.$380.met1 VDD.$381.met1 0.195652173913
Rext_3336 VDD.$380.met1 VDD.$88.li1 9.3
Rext_3337 VDD.$381.met1 VDD.$382.met1 0.195652173913
Rext_3338 VDD.$381.met1 VDD.$90.li1 9.3
Rext_3339 VDD.$382.met1 VDD.$383.met1 0.195652173913
Rext_3340 VDD.$382.met1 VDD.$92.li1 9.3
Rext_3341 VDD.$383.met1 VDD.$384.met1 0.195652173913
Rext_3342 VDD.$383.met1 VDD.$94.li1 9.3
Rext_3343 VDD.$384.met1 VDD.$385.met1 0.195652173913
Rext_3344 VDD.$384.met1 VDD.$96.li1 9.3
Rext_3345 VDD.$385.met1 VDD.$386.met1 0.195652173913
Rext_3346 VDD.$385.met1 VDD.$98.li1 9.3
Rext_3347 VDD.$386.met1 VDD.$387.met1 0.195652173913
Rext_3348 VDD.$387.met1 VDD.$388.met1 0.195652173913
Rext_3349 VDD.$388.met1 VDD.$389.met1 0.195652173913
Rext_3350 VDD.$389.met1 VDD.$390.met1 0.195652173913
Rext_3351 VDD.$390.met1 VDD.$391.met1 0.195652173913
Rext_3352 VDD.$392.met1 VDD.$481.met2 4.5
Rext_3353 VDD.$394.met1 VDD.$416.met1 0.0298913043478
Rext_3354 VDD.$395.met1 VDD.$396.met1 0.195652173913
Rext_3355 VDD.$395.met1 VDD.$416.met1 0.165760869565
Rext_3356 VDD.$396.met1 VDD.$397.met1 0.195652173913
Rext_3357 VDD.$397.met1 VDD.$398.met1 0.195652173913
Rext_3358 VDD.$398.met1 VDD.$399.met1 0.195652173913
Rext_3359 VDD.$399.met1 VDD.$400.met1 0.195652173913
Rext_3360 VDD.$4.li1 VDD.$6.li1 27.1058823529
Rext_3361 VDD.$4.li1 VDD.P3.psdm 585
Rext_3362 VDD.$40.li1 VDD.$42.li1 27.1058823529
Rext_3363 VDD.$40.li1 VDD.P3.psdm 585
Rext_3364 VDD.$400.met1 VDD.$401.met1 0.195652173913
Rext_3365 VDD.$401.met1 VDD.$402.met1 0.195652173913
Rext_3366 VDD.$402.met1 VDD.$403.met1 0.195652173913
Rext_3367 VDD.$403.met1 VDD.$404.met1 0.195652173913
Rext_3368 VDD.$404.met1 VDD.$405.met1 0.195652173913
Rext_3369 VDD.$405.met1 VDD.$406.met1 0.195652173913
Rext_3370 VDD.$406.met1 VDD.$407.met1 0.195652173913
Rext_3371 VDD.$407.met1 VDD.$408.met1 0.195652173913
Rext_3372 VDD.$408.met1 VDD.$409.met1 0.195652173913
Rext_3373 VDD.$409.met1 VDD.$410.met1 0.195652173913
Rext_3374 VDD.$410.met1 VDD.$411.met1 0.195652173913
Rext_3375 VDD.$411.met1 VDD.$412.met1 0.195652173913
Rext_3376 VDD.$412.met1 VDD.$413.met1 0.195652173913
Rext_3377 VDD.$413.met1 VDD.$414.met1 0.195652173913
Rext_3378 VDD.$414.met1 VDD.$415.met1 0.195652173913
Rext_3379 VDD.$416.met1 VDD.$482.met2 4.5
Rext_3380 VDD.$417.met1 VDD.$484.met2 4.5
Rext_3381 VDD.$419.met1 VDD.$420.met1 0.0298913043478
Rext_3382 VDD.$419.met1 VDD.$421.met1 0.165760869565
Rext_3383 VDD.$419.met1 VDD.$486.met2 4.5
Rext_3384 VDD.$42.li1 VDD.P3.psdm 585
Rext_3385 VDD.$421.met1 VDD.$422.met1 0.195652173913
Rext_3386 VDD.$422.met1 VDD.$423.met1 0.195652173913
Rext_3387 VDD.$423.met1 VDD.$424.met1 0.195652173913
Rext_3388 VDD.$424.met1 VDD.$425.met1 0.195652173913
Rext_3389 VDD.$425.met1 VDD.$426.met1 0.195652173913
Rext_3390 VDD.$426.met1 VDD.$427.met1 0.195652173913
Rext_3391 VDD.$427.met1 VDD.$428.met1 0.195652173913
Rext_3392 VDD.$428.met1 VDD.$429.met1 0.195652173913
Rext_3393 VDD.$429.met1 VDD.$430.met1 0.195652173913
Rext_3394 VDD.$430.met1 VDD.$431.met1 0.195652173913
Rext_3395 VDD.$431.met1 VDD.$432.met1 0.195652173913
Rext_3396 VDD.$432.met1 VDD.$433.met1 0.195652173913
Rext_3397 VDD.$433.met1 VDD.$434.met1 0.195652173913
Rext_3398 VDD.$434.met1 VDD.$435.met1 0.195652173913
Rext_3399 VDD.$435.met1 VDD.$436.met1 0.195652173913
Rext_3400 VDD.$436.met1 VDD.$437.met1 0.195652173913
Rext_3401 VDD.$437.met1 VDD.$438.met1 0.195652173913
Rext_3402 VDD.$438.met1 VDD.$439.met1 0.195652173913
Rext_3403 VDD.$439.met1 VDD.$440.met1 0.195652173913
Rext_3404 VDD.$44.li1 VDD.$45.li1 27.1058823529
Rext_3405 VDD.$44.li1 VDD.$662.nwell 185
Rext_3406 VDD.$440.met1 VDD.$441.met1 0.195652173913
Rext_3407 VDD.$442.met1 VDD.$487.met2 4.5
Rext_3408 VDD.$444.met1 VDD.$455.met1 0.0570652173913
Rext_3409 VDD.$445.met1 VDD.$446.met1 0.195652173913
Rext_3410 VDD.$445.met1 VDD.$455.met1 0.138586956522
Rext_3411 VDD.$446.met1 VDD.$447.met1 0.195652173913
Rext_3412 VDD.$447.met1 VDD.$448.met1 0.195652173913
Rext_3413 VDD.$448.met1 VDD.$449.met1 0.195652173913
Rext_3414 VDD.$449.met1 VDD.$450.met1 0.195652173913
Rext_3415 VDD.$45.li1 VDD.$46.li1 27.1058823529
Rext_3416 VDD.$45.li1 VDD.$663.nwell 185
Rext_3417 VDD.$450.met1 VDD.$451.met1 0.195652173913
Rext_3418 VDD.$451.met1 VDD.$452.met1 0.195652173913
Rext_3419 VDD.$452.met1 VDD.$453.met1 0.195652173913
Rext_3420 VDD.$453.met1 VDD.$454.met1 0.195652173913
Rext_3421 VDD.$455.met1 VDD.$488.met2 4.5
Rext_3422 VDD.$456.met1 VDD.$490.met2 4.5
Rext_3423 VDD.$458.met1 VDD.$459.met1 0.0570652173913
Rext_3424 VDD.$458.met1 VDD.$460.met1 0.138586956522
Rext_3425 VDD.$458.met1 VDD.$492.met2 4.5
Rext_3426 VDD.$46.li1 VDD.$47.li1 27.1058823529
Rext_3427 VDD.$46.li1 VDD.$664.nwell 185
Rext_3428 VDD.$460.met1 VDD.$461.met1 0.195652173913
Rext_3429 VDD.$461.met1 VDD.$462.met1 0.195652173913
Rext_3430 VDD.$462.met1 VDD.$463.met1 0.195652173913
Rext_3431 VDD.$463.met1 VDD.$464.met1 0.195652173913
Rext_3432 VDD.$464.met1 VDD.$465.met1 0.195652173913
Rext_3433 VDD.$465.met1 VDD.$466.met1 0.195652173913
Rext_3434 VDD.$466.met1 VDD.$467.met1 0.195652173913
Rext_3435 VDD.$467.met1 VDD.$468.met1 0.195652173913
Rext_3436 VDD.$468.met1 VDD.$469.met1 0.195652173913
Rext_3437 VDD.$47.li1 VDD.$48.li1 27.1058823529
Rext_3438 VDD.$47.li1 VDD.$665.nwell 185
Rext_3439 VDD.$470.met1 VDD.$493.met2 4.5
Rext_3440 VDD.$472.met1 VDD.$473.met1 0.0288532159628
Rext_3441 VDD.$472.met1 VDD.$496.met2 4.5
Rext_3442 VDD.$474.met1 VDD.$499.met2 4.5
Rext_3443 VDD.$476.met2 VDD.$477.met2 0.464469674702
Rext_3444 VDD.$476.met2 VDD.$500.met3 3.41
Rext_3445 VDD.$478.met2 VDD.$479.met2 1.73181818776
Rext_3446 VDD.$479.met2 VDD.$480.met2 0.349283960443
Rext_3447 VDD.$479.met2 VDD.$501.met3 3.41
Rext_3448 VDD.$48.li1 VDD.$49.li1 27.1058823529
Rext_3449 VDD.$48.li1 VDD.$666.nwell 185
Rext_3450 VDD.$481.met2 VDD.$483.met2 1.99809960473
Rext_3451 VDD.$482.met2 VDD.$483.met2 0.440940262938
Rext_3452 VDD.$483.met2 VDD.$502.met3 3.41
Rext_3453 VDD.$484.met2 VDD.$485.met2 1.75379712143
Rext_3454 VDD.$485.met2 VDD.$486.met2 0.404173330056
Rext_3455 VDD.$485.met2 VDD.$503.met3 3.41
Rext_3456 VDD.$487.met2 VDD.$489.met2 1.95282359028
Rext_3457 VDD.$488.met2 VDD.$489.met2 0.368242475142
Rext_3458 VDD.$489.met2 VDD.$504.met3 3.41
Rext_3459 VDD.$49.li1 VDD.$50.li1 27.1058823529
Rext_3460 VDD.$49.li1 VDD.$667.nwell 185
Rext_3461 VDD.$490.met2 VDD.$491.met2 1.11327034844
Rext_3462 VDD.$491.met2 VDD.$492.met2 0.464635427746
Rext_3463 VDD.$491.met2 VDD.$505.met3 3.41
Rext_3464 VDD.$493.met2 VDD.$494.met2 0.364277895125
Rext_3465 VDD.$494.met2 VDD.$495.met2 1.00900877885
Rext_3466 VDD.$494.met2 VDD.$506.met3 3.41
Rext_3467 VDD.$495.met2 VDD.$496.met2 0.0119070916716
Rext_3468 VDD.$495.met2 VDD.$507.met3 3.41
Rext_3469 VDD.$497.met2 VDD.$498.met2 10.953013162
Rext_3470 VDD.$497.met2 VDD.$508.met3 3.41
Rext_3471 VDD.$498.met2 VDD.$499.met2 0.0809333857714
Rext_3472 VDD.$498.met2 VDD.$509.met3 3.41
Rext_3473 VDD.$50.li1 VDD.$51.li1 27.1058823529
Rext_3474 VDD.$50.li1 VDD.$668.nwell 185
Rext_3475 VDD.$500.met3 VDD.$501.met3 0.846
Rext_3476 VDD.$501.met3 VDD.$502.met3 0.846
Rext_3477 VDD.$502.met3 VDD.$503.met3 0.74025
Rext_3478 VDD.$503.met3 VDD.$504.met3 0.846
Rext_3479 VDD.$504.met3 VDD.$505.met3 0.74025
Rext_3480 VDD.$505.met3 VDD.$506.met3 0.6345
Rext_3481 VDD.$507.met3 VDD.$509.met3 0.95175
Rext_3482 VDD.$508.met3 VDD.$510.met3 1.37475
Rext_3483 VDD.$51.li1 VDD.$52.li1 27.1058823529
Rext_3484 VDD.$51.li1 VDD.$669.nwell 185
Rext_3485 VDD.$510.met3 VDD.$586.met4 3.41
Rext_3486 VDD.$511.met3 VDD.$587.met4 3.41
Rext_3487 VDD.$511.met3 VDD.$588.met4 3.41
Rext_3488 VDD.$511.met3 VDD.$589.met4 3.41
Rext_3489 VDD.$511.met3 VDD.$590.met4 3.41
Rext_3490 VDD.$511.met3 VDD.$591.met4 3.41
Rext_3491 VDD.$511.met3 VDD.$592.met4 3.41
Rext_3492 VDD.$511.met3 VDD.$593.met4 3.41
Rext_3493 VDD.$511.met3 VDD.$594.met4 3.41
Rext_3494 VDD.$511.met3 VDD.$595.met4 3.41
Rext_3495 VDD.$511.met3 VDD.$596.met4 3.41
Rext_3496 VDD.$511.met3 VDD.$597.met4 3.41
Rext_3497 VDD.$511.met3 VDD.$598.met4 3.41
Rext_3498 VDD.$511.met3 VDD.$599.met4 3.41
Rext_3499 VDD.$511.met3 VDD.$600.met4 3.41
Rext_3500 VDD.$511.met3 VDD.$601.met4 3.41
Rext_3501 VDD.$511.met3 VDD.$602.met4 3.41
Rext_3502 VDD.$511.met3 VDD.$603.met4 3.41
Rext_3503 VDD.$511.met3 VDD.$604.met4 3.41
Rext_3504 VDD.$511.met3 VDD.$605.met4 3.41
Rext_3505 VDD.$511.met3 VDD.$606.met4 3.41
Rext_3506 VDD.$511.met3 VDD.$607.met4 3.41
Rext_3507 VDD.$511.met3 VDD.$608.met4 3.41
Rext_3508 VDD.$511.met3 VDD.$609.met4 3.41
Rext_3509 VDD.$511.met3 VDD.$610.met4 3.41
Rext_3510 VDD.$511.met3 VDD.$611.met4 3.41
Rext_3511 VDD.$511.met3 VDD.$612.met4 3.41
Rext_3512 VDD.$511.met3 VDD.$613.met4 3.41
Rext_3513 VDD.$511.met3 VDD.$614.met4 3.41
Rext_3514 VDD.$511.met3 VDD.$615.met4 3.41
Rext_3515 VDD.$511.met3 VDD.$616.met4 3.41
Rext_3516 VDD.$511.met3 VDD.$617.met4 3.41
Rext_3517 VDD.$511.met3 VDD.$618.met4 3.41
Rext_3518 VDD.$511.met3 VDD.$619.met4 3.41
Rext_3519 VDD.$511.met3 VDD.$620.met4 3.41
Rext_3520 VDD.$511.met3 VDD.$621.met4 3.41
Rext_3521 VDD.$511.met3 VDD.$622.met4 3.41
Rext_3522 VDD.$511.met3 VDD.$623.met4 3.41
Rext_3523 VDD.$511.met3 VDD.$624.met4 3.41
Rext_3524 VDD.$511.met3 VDD.$625.met4 3.41
Rext_3525 VDD.$511.met3 VDD.$626.met4 3.41
Rext_3526 VDD.$511.met3 VDD.$627.met4 3.41
Rext_3527 VDD.$511.met3 VDD.$628.met4 3.41
Rext_3528 VDD.$511.met3 VDD.$629.met4 3.41
Rext_3529 VDD.$511.met3 VDD.$630.met4 3.41
Rext_3530 VDD.$511.met3 VDD.$631.met4 3.41
Rext_3531 VDD.$511.met3 VDD.$632.met4 3.41
Rext_3532 VDD.$511.met3 VDD.$633.met4 3.41
Rext_3533 VDD.$511.met3 VDD.$634.met4 3.41
Rext_3534 VDD.$511.met3 VDD.$635.met4 3.41
Rext_3535 VDD.$511.met3 VDD.$636.met4 3.41
Rext_3536 VDD.$511.met3 VDD.$637.met4 3.41
Rext_3537 VDD.$511.met3 VDD.$638.met4 3.41
Rext_3538 VDD.$511.met3 VDD.$639.met4 3.41
Rext_3539 VDD.$511.met3 VDD.$640.met4 3.41
Rext_3540 VDD.$511.met3 VDD.$641.met4 3.41
Rext_3541 VDD.$511.met3 VDD.$642.met4 3.41
Rext_3542 VDD.$511.met3 VDD.$643.met4 3.41
Rext_3543 VDD.$511.met3 VDD.$644.met4 3.41
Rext_3544 VDD.$511.met3 VDD.$645.met4 3.41
Rext_3545 VDD.$511.met3 VDD.$646.met4 3.41
Rext_3546 VDD.$511.met3 VDD.$647.met4 3.41
Rext_3547 VDD.$511.met3 VDD.$648.met4 3.41
Rext_3548 VDD.$511.met3 VDD.$649.met4 3.41
Rext_3549 VDD.$511.met3 VDD.$650.met4 3.41
Rext_3550 VDD.$511.met3 VDD.$651.met4 3.41
Rext_3551 VDD.$511.met3 VDD.$652.met4 3.41
Rext_3552 VDD.$511.met3 VDD.$653.met4 3.41
Rext_3553 VDD.$511.met3 VDD.$654.met4 3.41
Rext_3554 VDD.$511.met3 VDD.$655.met4 3.41
Rext_3555 VDD.$511.met3 VDD.$656.met4 3.41
Rext_3556 VDD.$511.met3 VDD.$657.met4 3.41
Rext_3557 VDD.$511.met3 VDD.$658.met4 3.41
Rext_3558 VDD.$511.met3 VDD.$659.met4 3.41
Rext_3559 VDD.$511.met3 VDD.$660.met4 3.41
Rext_3560 VDD.$511.met3 VDD.$661.met4 3.41
Rext_3561 VDD.$511.met3 VDD.P0.met3 0.0253552631579
Rext_3562 VDD.$52.li1 VDD.$53.li1 27.1058823529
Rext_3563 VDD.$52.li1 VDD.$670.nwell 185
Rext_3564 VDD.$53.li1 VDD.$54.li1 27.1058823529
Rext_3565 VDD.$53.li1 VDD.$671.nwell 185
Rext_3566 VDD.$54.li1 VDD.$66.li1 13.5529411765
Rext_3567 VDD.$54.li1 VDD.$672.nwell 185
Rext_3568 VDD.$55.li1 VDD.$56.li1 27.1058823529
Rext_3569 VDD.$55.li1 VDD.$66.li1 13.5529411765
Rext_3570 VDD.$55.li1 VDD.$673.nwell 185
Rext_3571 VDD.$56.li1 VDD.$57.li1 27.1058823529
Rext_3572 VDD.$56.li1 VDD.$674.nwell 185
Rext_3573 VDD.$57.li1 VDD.$58.li1 27.1058823529
Rext_3574 VDD.$57.li1 VDD.$675.nwell 185
Rext_3575 VDD.$58.li1 VDD.$59.li1 27.1058823529
Rext_3576 VDD.$58.li1 VDD.$676.nwell 185
Rext_3577 VDD.$586.met4 VDD.$661.met4 0.250965391881
Rext_3578 VDD.$587.met4 VDD.$588.met4 0.0391666666667
Rext_3579 VDD.$588.met4 VDD.$589.met4 0.0391666666667
Rext_3580 VDD.$589.met4 VDD.$590.met4 0.0391666666667
Rext_3581 VDD.$59.li1 VDD.$60.li1 27.1058823529
Rext_3582 VDD.$59.li1 VDD.$677.nwell 185
Rext_3583 VDD.$590.met4 VDD.$591.met4 0.0391666666667
Rext_3584 VDD.$591.met4 VDD.$592.met4 0.0391666666667
Rext_3585 VDD.$592.met4 VDD.$593.met4 0.0391666666667
Rext_3586 VDD.$593.met4 VDD.$594.met4 0.0391666666667
Rext_3587 VDD.$594.met4 VDD.$595.met4 0.0391666666667
Rext_3588 VDD.$595.met4 VDD.$596.met4 0.0391666666667
Rext_3589 VDD.$596.met4 VDD.$597.met4 0.0391666666667
Rext_3590 VDD.$597.met4 VDD.$598.met4 0.0391666666667
Rext_3591 VDD.$598.met4 VDD.$599.met4 0.0391666666667
Rext_3592 VDD.$599.met4 VDD.$600.met4 0.0391666666667
Rext_3593 VDD.$6.li1 VDD.$8.li1 27.1058823529
Rext_3594 VDD.$6.li1 VDD.P3.psdm 585
Rext_3595 VDD.$60.li1 VDD.$61.li1 27.1058823529
Rext_3596 VDD.$60.li1 VDD.$678.nwell 185
Rext_3597 VDD.$600.met4 VDD.$601.met4 0.0391666666667
Rext_3598 VDD.$601.met4 VDD.$602.met4 0.0391666666667
Rext_3599 VDD.$602.met4 VDD.$603.met4 0.0391666666667
Rext_3600 VDD.$603.met4 VDD.$604.met4 0.0391666666667
Rext_3601 VDD.$604.met4 VDD.$605.met4 0.0391666666667
Rext_3602 VDD.$605.met4 VDD.$606.met4 0.0391666666667
Rext_3603 VDD.$606.met4 VDD.$607.met4 0.0391666666667
Rext_3604 VDD.$607.met4 VDD.$608.met4 0.0391666666667
Rext_3605 VDD.$608.met4 VDD.$609.met4 0.0391666666667
Rext_3606 VDD.$609.met4 VDD.$610.met4 0.0391666666667
Rext_3607 VDD.$61.li1 VDD.$62.li1 27.1058823529
Rext_3608 VDD.$61.li1 VDD.$679.nwell 185
Rext_3609 VDD.$610.met4 VDD.$611.met4 0.0391666666667
Rext_3610 VDD.$611.met4 VDD.$612.met4 0.0391666666667
Rext_3611 VDD.$612.met4 VDD.$613.met4 0.0391666666667
Rext_3612 VDD.$613.met4 VDD.$614.met4 0.0391666666667
Rext_3613 VDD.$614.met4 VDD.$615.met4 0.0391666666667
Rext_3614 VDD.$615.met4 VDD.$616.met4 0.0391666666667
Rext_3615 VDD.$616.met4 VDD.$617.met4 0.0391666666667
Rext_3616 VDD.$617.met4 VDD.$618.met4 0.0391666666667
Rext_3617 VDD.$618.met4 VDD.$619.met4 0.0391666666667
Rext_3618 VDD.$619.met4 VDD.$620.met4 0.0391666666667
Rext_3619 VDD.$62.li1 VDD.$63.li1 27.1058823529
Rext_3620 VDD.$62.li1 VDD.$680.nwell 185
Rext_3621 VDD.$620.met4 VDD.$621.met4 0.0391666666667
Rext_3622 VDD.$621.met4 VDD.$622.met4 0.0391666666667
Rext_3623 VDD.$622.met4 VDD.$623.met4 0.0391666666667
Rext_3624 VDD.$623.met4 VDD.$624.met4 0.0391666666667
Rext_3625 VDD.$624.met4 VDD.$625.met4 0.0391666666667
Rext_3626 VDD.$625.met4 VDD.$626.met4 0.0391666666667
Rext_3627 VDD.$626.met4 VDD.$627.met4 0.0391666666667
Rext_3628 VDD.$627.met4 VDD.$628.met4 0.0391666666667
Rext_3629 VDD.$628.met4 VDD.$629.met4 0.0391666666667
Rext_3630 VDD.$629.met4 VDD.$630.met4 0.0391666666667
Rext_3631 VDD.$63.li1 VDD.$64.li1 27.1058823529
Rext_3632 VDD.$63.li1 VDD.$681.nwell 185
Rext_3633 VDD.$630.met4 VDD.$631.met4 0.0391666666667
Rext_3634 VDD.$631.met4 VDD.$632.met4 0.0391666666667
Rext_3635 VDD.$632.met4 VDD.$633.met4 0.0391666666667
Rext_3636 VDD.$633.met4 VDD.$634.met4 0.0391666666667
Rext_3637 VDD.$634.met4 VDD.$635.met4 0.0391666666667
Rext_3638 VDD.$635.met4 VDD.$636.met4 0.0391666666667
Rext_3639 VDD.$636.met4 VDD.$637.met4 0.0391666666667
Rext_3640 VDD.$637.met4 VDD.$638.met4 0.0391666666667
Rext_3641 VDD.$638.met4 VDD.$639.met4 0.0391666666667
Rext_3642 VDD.$639.met4 VDD.$640.met4 0.0391666666667
Rext_3643 VDD.$64.li1 VDD.$65.li1 27.1058823529
Rext_3644 VDD.$64.li1 VDD.$682.nwell 185
Rext_3645 VDD.$640.met4 VDD.$641.met4 0.0391666666667
Rext_3646 VDD.$641.met4 VDD.$642.met4 0.0391666666667
Rext_3647 VDD.$642.met4 VDD.$643.met4 0.0391666666667
Rext_3648 VDD.$643.met4 VDD.$644.met4 0.0391666666667
Rext_3649 VDD.$644.met4 VDD.$645.met4 0.0391666666667
Rext_3650 VDD.$645.met4 VDD.$646.met4 0.0391666666667
Rext_3651 VDD.$646.met4 VDD.$647.met4 0.0391666666667
Rext_3652 VDD.$647.met4 VDD.$648.met4 0.0391666666667
Rext_3653 VDD.$648.met4 VDD.$649.met4 0.0391666666667
Rext_3654 VDD.$649.met4 VDD.$650.met4 0.0391666666667
Rext_3655 VDD.$65.li1 VDD.$683.nwell 185
Rext_3656 VDD.$650.met4 VDD.$651.met4 0.0391666666667
Rext_3657 VDD.$651.met4 VDD.$652.met4 0.0391666666667
Rext_3658 VDD.$652.met4 VDD.$653.met4 0.0391666666667
Rext_3659 VDD.$653.met4 VDD.$654.met4 0.0391666666667
Rext_3660 VDD.$654.met4 VDD.$655.met4 0.0391666666667
Rext_3661 VDD.$655.met4 VDD.$656.met4 0.0391666666667
Rext_3662 VDD.$656.met4 VDD.$657.met4 0.0391666666667
Rext_3663 VDD.$657.met4 VDD.$658.met4 0.0408835282118
Rext_3664 VDD.$659.met4 VDD.$660.met4 0.0254625365016
Rext_3665 VDD.$66.li1 VDD.$67.li1 20.0827586207
Rext_3666 VDD.$660.met4 VDD.$661.met4 0.0254054054054
Rext_3667 VDD.$662.nwell VDD.$663.nwell 109.285714286
Rext_3668 VDD.$663.nwell VDD.$664.nwell 109.285714286
Rext_3669 VDD.$664.nwell VDD.$665.nwell 109.285714286
Rext_3670 VDD.$665.nwell VDD.$666.nwell 109.285714286
Rext_3671 VDD.$666.nwell VDD.$667.nwell 109.285714286
Rext_3672 VDD.$667.nwell VDD.$668.nwell 109.285714286
Rext_3673 VDD.$668.nwell VDD.$669.nwell 109.285714286
Rext_3674 VDD.$669.nwell VDD.$670.nwell 109.285714286
Rext_3675 VDD.$670.nwell VDD.$671.nwell 109.285714286
Rext_3676 VDD.$671.nwell VDD.$672.nwell 109.285714286
Rext_3677 VDD.$672.nwell VDD.P3.nwell 54.6428571429
Rext_3678 VDD.$673.nwell VDD.$674.nwell 109.285714286
Rext_3679 VDD.$673.nwell VDD.P3.nwell 54.6428571429
Rext_3680 VDD.$674.nwell VDD.$675.nwell 109.285714286
Rext_3681 VDD.$675.nwell VDD.$676.nwell 109.285714286
Rext_3682 VDD.$676.nwell VDD.$677.nwell 109.285714286
Rext_3683 VDD.$677.nwell VDD.$678.nwell 109.285714286
Rext_3684 VDD.$678.nwell VDD.$679.nwell 109.285714286
Rext_3685 VDD.$679.nwell VDD.$680.nwell 109.285714286
Rext_3686 VDD.$68.li1 VDD.$70.li1 27.1058823529
Rext_3687 VDD.$68.li1 VDD.P6.psdm 585
Rext_3688 VDD.$680.nwell VDD.$681.nwell 109.285714286
Rext_3689 VDD.$681.nwell VDD.$682.nwell 109.285714286
Rext_3690 VDD.$682.nwell VDD.$683.nwell 109.285714286
Rext_3691 VDD.$684.nwell VDD.$685.nwell 109.285714286
Rext_3692 VDD.$685.nwell VDD.$686.nwell 109.285714286
Rext_3693 VDD.$686.nwell VDD.$687.nwell 109.285714286
Rext_3694 VDD.$687.nwell VDD.$688.nwell 109.285714286
Rext_3695 VDD.$688.nwell VDD.$689.nwell 109.285714286
Rext_3696 VDD.$689.nwell VDD.$690.nwell 109.285714286
Rext_3697 VDD.$690.nwell VDD.$691.nwell 109.285714286
Rext_3698 VDD.$691.nwell VDD.$692.nwell 109.285714286
Rext_3699 VDD.$692.nwell VDD.$693.nwell 109.285714286
Rext_3700 VDD.$693.nwell VDD.$694.nwell 109.285714286
Rext_3701 VDD.$694.nwell VDD.P6.nwell 54.6428571429
Rext_3702 VDD.$695.nwell VDD.$696.nwell 109.285714286
Rext_3703 VDD.$695.nwell VDD.P6.nwell 54.6428571429
Rext_3704 VDD.$696.nwell VDD.$697.nwell 109.285714286
Rext_3705 VDD.$697.nwell VDD.$698.nwell 109.285714286
Rext_3706 VDD.$698.nwell VDD.$699.nwell 109.285714286
Rext_3707 VDD.$699.nwell VDD.$700.nwell 109.285714286
Rext_3708 VDD.$70.li1 VDD.$72.li1 27.1058823529
Rext_3709 VDD.$70.li1 VDD.P6.psdm 585
Rext_3710 VDD.$700.nwell VDD.$701.nwell 109.285714286
Rext_3711 VDD.$701.nwell VDD.$702.nwell 109.285714286
Rext_3712 VDD.$702.nwell VDD.$703.nwell 109.285714286
Rext_3713 VDD.$703.nwell VDD.$704.nwell 109.285714286
Rext_3714 VDD.$704.nwell VDD.$705.nwell 109.285714286
Rext_3715 VDD.$706.nwell VDD.$707.nwell 109.285714286
Rext_3716 VDD.$707.nwell VDD.$708.nwell 109.285714286
Rext_3717 VDD.$708.nwell VDD.$709.nwell 109.285714286
Rext_3718 VDD.$709.nwell VDD.$710.nwell 109.285714286
Rext_3719 VDD.$710.nwell VDD.$711.nwell 109.285714286
Rext_3720 VDD.$711.nwell VDD.$712.nwell 109.285714286
Rext_3721 VDD.$712.nwell VDD.$713.nwell 109.285714286
Rext_3722 VDD.$713.nwell VDD.$714.nwell 109.285714286
Rext_3723 VDD.$714.nwell VDD.$715.nwell 109.285714286
Rext_3724 VDD.$715.nwell VDD.$716.nwell 109.285714286
Rext_3725 VDD.$716.nwell VDD.P5.nwell 54.6428571429
Rext_3726 VDD.$717.nwell VDD.$718.nwell 109.285714286
Rext_3727 VDD.$717.nwell VDD.P5.nwell 54.6428571429
Rext_3728 VDD.$718.nwell VDD.$719.nwell 109.285714286
Rext_3729 VDD.$719.nwell VDD.$720.nwell 109.285714286
Rext_3730 VDD.$72.li1 VDD.$74.li1 27.1058823529
Rext_3731 VDD.$72.li1 VDD.P6.psdm 585
Rext_3732 VDD.$720.nwell VDD.$721.nwell 109.285714286
Rext_3733 VDD.$721.nwell VDD.$722.nwell 109.285714286
Rext_3734 VDD.$722.nwell VDD.$723.nwell 109.285714286
Rext_3735 VDD.$723.nwell VDD.$724.nwell 109.285714286
Rext_3736 VDD.$724.nwell VDD.$725.nwell 109.285714286
Rext_3737 VDD.$725.nwell VDD.$726.nwell 109.285714286
Rext_3738 VDD.$726.nwell VDD.$727.nwell 109.285714286
Rext_3739 VDD.$728.nwell VDD.$729.nwell 109.285714286
Rext_3740 VDD.$729.nwell VDD.$730.nwell 109.285714286
Rext_3741 VDD.$730.nwell VDD.$731.nwell 109.285714286
Rext_3742 VDD.$731.nwell VDD.$732.nwell 109.285714286
Rext_3743 VDD.$732.nwell VDD.$733.nwell 109.285714286
Rext_3744 VDD.$733.nwell VDD.$734.nwell 109.285714286
Rext_3745 VDD.$734.nwell VDD.$735.nwell 109.285714286
Rext_3746 VDD.$735.nwell VDD.$736.nwell 109.285714286
Rext_3747 VDD.$736.nwell VDD.$737.nwell 109.285714286
Rext_3748 VDD.$737.nwell VDD.$738.nwell 109.285714286
Rext_3749 VDD.$738.nwell VDD.P4.nwell 54.6428571429
Rext_3750 VDD.$739.nwell VDD.$740.nwell 109.285714286
Rext_3751 VDD.$739.nwell VDD.P4.nwell 54.6428571429
Rext_3752 VDD.$74.li1 VDD.$76.li1 27.1058823529
Rext_3753 VDD.$74.li1 VDD.P6.psdm 585
Rext_3754 VDD.$740.nwell VDD.$741.nwell 109.285714286
Rext_3755 VDD.$741.nwell VDD.$742.nwell 109.285714286
Rext_3756 VDD.$742.nwell VDD.$743.nwell 109.285714286
Rext_3757 VDD.$743.nwell VDD.$744.nwell 109.285714286
Rext_3758 VDD.$744.nwell VDD.$745.nwell 109.285714286
Rext_3759 VDD.$745.nwell VDD.$746.nwell 109.285714286
Rext_3760 VDD.$746.nwell VDD.$747.nwell 109.285714286
Rext_3761 VDD.$747.nwell VDD.$748.nwell 109.285714286
Rext_3762 VDD.$748.nwell VDD.$749.nwell 109.285714286
Rext_3763 VDD.$750.nwell VDD.P1.nwell 779.6875
Rext_3764 VDD.$76.li1 VDD.$78.li1 27.1058823529
Rext_3765 VDD.$76.li1 VDD.P6.psdm 585
Rext_3766 VDD.$761.nwell VDD.P2.nwell 779.6875
Rext_3767 VDD.$772.nwell VDD.P0.nwell 4108.33333333
Rext_3768 VDD.$78.li1 VDD.$80.li1 27.1058823529
Rext_3769 VDD.$78.li1 VDD.P6.psdm 585
Rext_3770 VDD.$8.li1 VDD.P3.psdm 585
Rext_3771 VDD.$80.li1 VDD.$82.li1 27.1058823529
Rext_3772 VDD.$80.li1 VDD.P6.psdm 585
Rext_3773 VDD.$82.li1 VDD.$84.li1 27.1058823529
Rext_3774 VDD.$82.li1 VDD.P6.psdm 585
Rext_3775 VDD.$84.li1 VDD.$86.li1 27.1058823529
Rext_3776 VDD.$84.li1 VDD.P6.psdm 585
Rext_3777 VDD.$86.li1 VDD.$88.li1 27.1058823529
Rext_3778 VDD.$86.li1 VDD.P6.psdm 585
Rext_3779 VDD.$88.li1 VDD.$90.li1 27.1058823529
Rext_3780 VDD.$88.li1 VDD.P6.psdm 585
Rext_3781 VDD.$90.li1 VDD.$92.li1 27.1058823529
Rext_3782 VDD.$90.li1 VDD.P6.psdm 585
Rext_3783 VDD.$92.li1 VDD.$94.li1 27.1058823529
Rext_3784 VDD.$92.li1 VDD.P6.psdm 585
Rext_3785 VDD.$94.li1 VDD.$96.li1 27.1058823529
Rext_3786 VDD.$94.li1 VDD.P6.psdm 585
Rext_3787 VDD.$96.li1 VDD.$98.li1 27.1058823529
Rext_3788 VDD.$96.li1 VDD.P6.psdm 585
Rext_3789 VDD.$98.li1 VDD.P6.psdm 585
Rext_3790 VREF VREF.$102.met2 0.3125
Rext_3791 VREF VREF.$104.met2 0.003125
Rext_3792 VREF.$0.li1 VREF.$2.li1 27.1058823529
Rext_3793 VREF.$0.li1 VREF.$63.met1 9.3
Rext_3794 VREF.$0.li1 VREF.P0.psdm 585
Rext_3795 VREF.$10.li1 VREF.$12.li1 27.1058823529
Rext_3796 VREF.$10.li1 VREF.$68.met1 9.3
Rext_3797 VREF.$10.li1 VREF.$8.li1 27.1058823529
Rext_3798 VREF.$10.li1 VREF.P0.psdm 585
Rext_3799 VREF.$100.met2 VREF.$101.met2 5.32665475808
Rext_3800 VREF.$100.met2 VREF.$107.met3 3.41
Rext_3801 VREF.$101.met2 VREF.$85.met1 4.5
Rext_3802 VREF.$102.met2 VREF.$108.met3 3.41
Rext_3803 VREF.$103.met2 VREF.$104.met2 1.559375
Rext_3804 VREF.$103.met2 VREF.$109.met3 3.41
Rext_3805 VREF.$104.met2 VREF.$88.met1 4.5
Rext_3806 VREF.$105.met2 VREF.$106.met2 3.47230767517
Rext_3807 VREF.$105.met2 VREF.$110.met3 3.41
Rext_3808 VREF.$106.met2 VREF.$93.met1 4.5
Rext_3809 VREF.$107.met3 VREF.$109.met3 1.0575
Rext_3810 VREF.$108.met3 VREF.$110.met3 3.91275
Rext_3811 VREF.$111.poly VREF.$44.li1 152
Rext_3812 VREF.$111.poly VREF.$48.li1 152
Rext_3813 VREF.$111.poly VREF.$52.li1 152
Rext_3814 VREF.$111.poly VREF.P0.poly 41.693
Rext_3815 VREF.$112.poly VREF.$46.li1 152
Rext_3816 VREF.$112.poly VREF.$50.li1 152
Rext_3817 VREF.$112.poly VREF.$54.li1 152
Rext_3818 VREF.$112.poly VREF.P0.poly 41.693
Rext_3819 VREF.$117.poly VREF.$56.li1 11.56
Rext_3820 VREF.$117.poly VREF.P1.poly 4.13142857143
Rext_3821 VREF.$12.li1 VREF.$14.li1 27.1058823529
Rext_3822 VREF.$12.li1 VREF.$69.met1 9.3
Rext_3823 VREF.$12.li1 VREF.P0.psdm 585
Rext_3824 VREF.$14.li1 VREF.$16.li1 27.1058823529
Rext_3825 VREF.$14.li1 VREF.$70.met1 9.3
Rext_3826 VREF.$14.li1 VREF.P0.psdm 585
Rext_3827 VREF.$16.li1 VREF.$18.li1 27.1058823529
Rext_3828 VREF.$16.li1 VREF.$71.met1 9.3
Rext_3829 VREF.$16.li1 VREF.P0.psdm 585
Rext_3830 VREF.$18.li1 VREF.$20.li1 27.1058823529
Rext_3831 VREF.$18.li1 VREF.$72.met1 9.3
Rext_3832 VREF.$18.li1 VREF.P0.psdm 585
Rext_3833 VREF.$2.li1 VREF.$4.li1 27.1058823529
Rext_3834 VREF.$2.li1 VREF.$64.met1 9.3
Rext_3835 VREF.$2.li1 VREF.P0.psdm 585
Rext_3836 VREF.$20.li1 VREF.$22.li1 27.1058823529
Rext_3837 VREF.$20.li1 VREF.$73.met1 9.3
Rext_3838 VREF.$20.li1 VREF.P0.psdm 585
Rext_3839 VREF.$22.li1 VREF.$24.li1 27.1058823529
Rext_3840 VREF.$22.li1 VREF.$74.met1 9.3
Rext_3841 VREF.$22.li1 VREF.P0.psdm 585
Rext_3842 VREF.$24.li1 VREF.$26.li1 27.1058823529
Rext_3843 VREF.$24.li1 VREF.$75.met1 9.3
Rext_3844 VREF.$24.li1 VREF.P0.psdm 585
Rext_3845 VREF.$26.li1 VREF.$28.li1 27.1058823529
Rext_3846 VREF.$26.li1 VREF.$76.met1 9.3
Rext_3847 VREF.$26.li1 VREF.P0.psdm 585
Rext_3848 VREF.$28.li1 VREF.$30.li1 27.1058823529
Rext_3849 VREF.$28.li1 VREF.$77.met1 9.3
Rext_3850 VREF.$28.li1 VREF.P0.psdm 585
Rext_3851 VREF.$30.li1 VREF.$32.li1 27.1058823529
Rext_3852 VREF.$30.li1 VREF.$78.met1 9.3
Rext_3853 VREF.$30.li1 VREF.P0.psdm 585
Rext_3854 VREF.$32.li1 VREF.$34.li1 27.1058823529
Rext_3855 VREF.$32.li1 VREF.$79.met1 9.3
Rext_3856 VREF.$32.li1 VREF.P0.psdm 585
Rext_3857 VREF.$34.li1 VREF.$36.li1 27.1058823529
Rext_3858 VREF.$34.li1 VREF.$80.met1 9.3
Rext_3859 VREF.$34.li1 VREF.P0.psdm 585
Rext_3860 VREF.$36.li1 VREF.$38.li1 27.1058823529
Rext_3861 VREF.$36.li1 VREF.$81.met1 9.3
Rext_3862 VREF.$36.li1 VREF.P0.psdm 585
Rext_3863 VREF.$38.li1 VREF.$40.li1 27.1058823529
Rext_3864 VREF.$38.li1 VREF.$82.met1 9.3
Rext_3865 VREF.$38.li1 VREF.P0.psdm 585
Rext_3866 VREF.$4.li1 VREF.$6.li1 27.1058823529
Rext_3867 VREF.$4.li1 VREF.$65.met1 9.3
Rext_3868 VREF.$4.li1 VREF.P0.psdm 585
Rext_3869 VREF.$40.li1 VREF.$42.li1 27.1058823529
Rext_3870 VREF.$40.li1 VREF.$83.met1 9.3
Rext_3871 VREF.$40.li1 VREF.P0.psdm 585
Rext_3872 VREF.$42.li1 VREF.$84.met1 9.3
Rext_3873 VREF.$42.li1 VREF.P0.psdm 585
Rext_3874 VREF.$44.li1 VREF.$48.li1 27.1058823529
Rext_3875 VREF.$44.li1 VREF.$86.met1 9.3
Rext_3876 VREF.$46.li1 VREF.$50.li1 27.1058823529
Rext_3877 VREF.$46.li1 VREF.$87.met1 9.3
Rext_3878 VREF.$48.li1 VREF.$52.li1 27.1058823529
Rext_3879 VREF.$48.li1 VREF.$89.met1 9.3
Rext_3880 VREF.$50.li1 VREF.$54.li1 27.1058823529
Rext_3881 VREF.$50.li1 VREF.$90.met1 9.3
Rext_3882 VREF.$52.li1 VREF.$91.met1 9.3
Rext_3883 VREF.$54.li1 VREF.$92.met1 9.3
Rext_3884 VREF.$56.li1 VREF.$59.li1 6.58285714286
Rext_3885 VREF.$56.li1 VREF.$60.li1 6.58285714286
Rext_3886 VREF.$57.li1 VREF.$58.li1 13.1657142857
Rext_3887 VREF.$57.li1 VREF.$93.met1 9.3
Rext_3888 VREF.$58.li1 VREF.$59.li1 13.1657142857
Rext_3889 VREF.$58.li1 VREF.$95.met1 9.3
Rext_3890 VREF.$59.li1 VREF.$96.met1 9.3
Rext_3891 VREF.$6.li1 VREF.$66.met1 9.3
Rext_3892 VREF.$6.li1 VREF.$8.li1 27.1058823529
Rext_3893 VREF.$6.li1 VREF.P0.psdm 585
Rext_3894 VREF.$60.li1 VREF.$61.li1 13.1657142857
Rext_3895 VREF.$60.li1 VREF.$97.met1 9.3
Rext_3896 VREF.$61.li1 VREF.$62.li1 13.1657142857
Rext_3897 VREF.$61.li1 VREF.$98.met1 9.3
Rext_3898 VREF.$62.li1 VREF.$99.met1 9.3
Rext_3899 VREF.$63.met1 VREF.$64.met1 0.0788043478261
Rext_3900 VREF.$63.met1 VREF.$85.met1 0.013671875
Rext_3901 VREF.$64.met1 VREF.$65.met1 0.195652173913
Rext_3902 VREF.$65.met1 VREF.$66.met1 0.195652173913
Rext_3903 VREF.$66.met1 VREF.$67.met1 0.195652173913
Rext_3904 VREF.$67.met1 VREF.$68.met1 0.195652173913
Rext_3905 VREF.$67.met1 VREF.$8.li1 9.3
Rext_3906 VREF.$68.met1 VREF.$69.met1 0.195652173913
Rext_3907 VREF.$69.met1 VREF.$70.met1 0.195652173913
Rext_3908 VREF.$70.met1 VREF.$71.met1 0.195652173913
Rext_3909 VREF.$71.met1 VREF.$72.met1 0.195652173913
Rext_3910 VREF.$72.met1 VREF.$73.met1 0.195652173913
Rext_3911 VREF.$73.met1 VREF.$74.met1 0.195652173913
Rext_3912 VREF.$74.met1 VREF.$75.met1 0.195652173913
Rext_3913 VREF.$75.met1 VREF.$76.met1 0.195652173913
Rext_3914 VREF.$76.met1 VREF.$77.met1 0.195652173913
Rext_3915 VREF.$77.met1 VREF.$78.met1 0.195652173913
Rext_3916 VREF.$78.met1 VREF.$79.met1 0.195652173913
Rext_3917 VREF.$79.met1 VREF.$80.met1 0.195652173913
Rext_3918 VREF.$8.li1 VREF.P0.psdm 585
Rext_3919 VREF.$80.met1 VREF.$81.met1 0.195652173913
Rext_3920 VREF.$81.met1 VREF.$82.met1 0.195652173913
Rext_3921 VREF.$82.met1 VREF.$83.met1 0.195652173913
Rext_3922 VREF.$83.met1 VREF.$84.met1 0.195652173913
Rext_3923 VREF.$86.met1 VREF.$88.met1 0.138586956522
Rext_3924 VREF.$87.met1 VREF.$90.met1 0.195652173913
Rext_3925 VREF.$88.met1 VREF.$89.met1 0.0570652173913
Rext_3926 VREF.$89.met1 VREF.$91.met1 0.195652173913
Rext_3927 VREF.$90.met1 VREF.$92.met1 0.195652173913
Rext_3928 VREF.$93.met1 VREF.$95.met1 0.1625
Rext_3929 VREF.$95.met1 VREF.$96.met1 0.18
Rext_3930 VREF.$96.met1 VREF.$97.met1 0.18
Rext_3931 VREF.$97.met1 VREF.$98.met1 0.18
Rext_3932 VREF.$98.met1 VREF.$99.met1 0.18
Rext_3933 VSS VSS.$396.met2 1.9891282863
Rext_3934 VSS VSS.$400.met2 0.131704479586
Rext_3935 VSS VSS.$424.met3 3.41
Rext_3936 VSS.$0.li1 VSS.$208.met1 9.3
Rext_3937 VSS.$0.li1 VSS.P0.li1 37.3701998049
Rext_3938 VSS.$1.li1 VSS.$209.met1 9.3
Rext_3939 VSS.$1.li1 VSS.P6.li1 34.1691056881
Rext_3940 VSS.$10.li1 VSS.$228.met1 9.3
Rext_3941 VSS.$10.li1 VSS.P14.li1 37.3701998049
Rext_3942 VSS.$100.li1 VSS.$101.li1 27.1058823529
Rext_3943 VSS.$100.li1 VSS.$291.met1 9.3
Rext_3944 VSS.$100.li1 VSS.$97.li1 27.1058823529
Rext_3945 VSS.$100.li1 VSS.P3.nsdm 185
Rext_3946 VSS.$101.li1 VSS.$103.li1 27.1058823529
Rext_3947 VSS.$101.li1 VSS.$292.met1 9.3
Rext_3948 VSS.$101.li1 VSS.P3.nsdm 185
Rext_3949 VSS.$103.li1 VSS.$105.li1 27.1058823529
Rext_3950 VSS.$103.li1 VSS.$293.met1 9.3
Rext_3951 VSS.$103.li1 VSS.P3.nsdm 185
Rext_3952 VSS.$105.li1 VSS.$107.li1 27.1058823529
Rext_3953 VSS.$105.li1 VSS.$294.met1 9.3
Rext_3954 VSS.$105.li1 VSS.P3.nsdm 185
Rext_3955 VSS.$107.li1 VSS.$295.met1 9.3
Rext_3956 VSS.$107.li1 VSS.P3.nsdm 185
Rext_3957 VSS.$109.li1 VSS.$296.met1 9.3
Rext_3958 VSS.$11.li1 VSS.$229.met1 9.3
Rext_3959 VSS.$11.li1 VSS.P18.li1 34.1691056881
Rext_3960 VSS.$110.li1 VSS.$298.met1 9.3
Rext_3961 VSS.$110.li1 VSS.P16.li1 34.1691056881
Rext_3962 VSS.$111.li1 VSS.$113.li1 27.1058823529
Rext_3963 VSS.$111.li1 VSS.$301.met1 9.3
Rext_3964 VSS.$111.li1 VSS.P1.nsdm 185
Rext_3965 VSS.$113.li1 VSS.$302.met1 9.3
Rext_3966 VSS.$113.li1 VSS.P1.nsdm 185
Rext_3967 VSS.$115.li1 VSS.$303.met1 9.3
Rext_3968 VSS.$116.li1 VSS.$305.met1 9.3
Rext_3969 VSS.$116.li1 VSS.P16.li1 37.3961292261
Rext_3970 VSS.$117.li1 VSS.$307.met1 9.3
Rext_3971 VSS.$117.li1 VSS.P0.nsdm 185
Rext_3972 VSS.$119.li1 VSS.$309.met1 9.3
Rext_3973 VSS.$12.li1 VSS.$230.met1 9.3
Rext_3974 VSS.$12.li1 VSS.P4.li1 34.1691056881
Rext_3975 VSS.$120.li1 VSS.$124.li1 27.1058823529
Rext_3976 VSS.$120.li1 VSS.$311.met1 9.3
Rext_3977 VSS.$120.li1 VSS.$477.poly 152
Rext_3978 VSS.$122.li1 VSS.$126.li1 27.1058823529
Rext_3979 VSS.$122.li1 VSS.$312.met1 9.3
Rext_3980 VSS.$122.li1 VSS.$477.poly 152
Rext_3981 VSS.$124.li1 VSS.$128.li1 27.1058823529
Rext_3982 VSS.$124.li1 VSS.$313.met1 9.3
Rext_3983 VSS.$124.li1 VSS.$479.poly 152
Rext_3984 VSS.$126.li1 VSS.$130.li1 27.1058823529
Rext_3985 VSS.$126.li1 VSS.$314.met1 9.3
Rext_3986 VSS.$126.li1 VSS.$479.poly 152
Rext_3987 VSS.$128.li1 VSS.$132.li1 27.1058823529
Rext_3988 VSS.$128.li1 VSS.$316.met1 9.3
Rext_3989 VSS.$128.li1 VSS.$481.poly 152
Rext_3990 VSS.$13.li1 VSS.$234.met1 9.3
Rext_3991 VSS.$130.li1 VSS.$134.li1 27.1058823529
Rext_3992 VSS.$130.li1 VSS.$317.met1 9.3
Rext_3993 VSS.$130.li1 VSS.$481.poly 152
Rext_3994 VSS.$132.li1 VSS.$136.li1 27.1058823529
Rext_3995 VSS.$132.li1 VSS.$318.met1 9.3
Rext_3996 VSS.$132.li1 VSS.$483.poly 152
Rext_3997 VSS.$134.li1 VSS.$138.li1 27.1058823529
Rext_3998 VSS.$134.li1 VSS.$319.met1 9.3
Rext_3999 VSS.$134.li1 VSS.$483.poly 152
Rext_4000 VSS.$136.li1 VSS.$140.li1 27.1058823529
Rext_4001 VSS.$136.li1 VSS.$320.met1 9.3
Rext_4002 VSS.$136.li1 VSS.$485.poly 152
Rext_4003 VSS.$138.li1 VSS.$142.li1 27.1058823529
Rext_4004 VSS.$138.li1 VSS.$321.met1 9.3
Rext_4005 VSS.$138.li1 VSS.$485.poly 152
Rext_4006 VSS.$14.li1 VSS.$16.li1 27.1058823529
Rext_4007 VSS.$14.li1 VSS.$236.met1 9.3
Rext_4008 VSS.$14.li1 VSS.P2.nsdm 185
Rext_4009 VSS.$140.li1 VSS.$144.li1 27.1058823529
Rext_4010 VSS.$140.li1 VSS.$322.met1 9.3
Rext_4011 VSS.$140.li1 VSS.$487.poly 152
Rext_4012 VSS.$142.li1 VSS.$146.li1 27.1058823529
Rext_4013 VSS.$142.li1 VSS.$323.met1 9.3
Rext_4014 VSS.$142.li1 VSS.$487.poly 152
Rext_4015 VSS.$144.li1 VSS.$148.li1 27.1058823529
Rext_4016 VSS.$144.li1 VSS.$324.met1 9.3
Rext_4017 VSS.$144.li1 VSS.$489.poly 152
Rext_4018 VSS.$146.li1 VSS.$150.li1 27.1058823529
Rext_4019 VSS.$146.li1 VSS.$325.met1 9.3
Rext_4020 VSS.$146.li1 VSS.$489.poly 152
Rext_4021 VSS.$148.li1 VSS.$152.li1 27.1058823529
Rext_4022 VSS.$148.li1 VSS.$326.met1 9.3
Rext_4023 VSS.$148.li1 VSS.$491.poly 152
Rext_4024 VSS.$150.li1 VSS.$154.li1 27.1058823529
Rext_4025 VSS.$150.li1 VSS.$327.met1 9.3
Rext_4026 VSS.$150.li1 VSS.$491.poly 152
Rext_4027 VSS.$152.li1 VSS.$156.li1 27.1058823529
Rext_4028 VSS.$152.li1 VSS.$328.met1 9.3
Rext_4029 VSS.$152.li1 VSS.$493.poly 152
Rext_4030 VSS.$154.li1 VSS.$158.li1 27.1058823529
Rext_4031 VSS.$154.li1 VSS.$329.met1 9.3
Rext_4032 VSS.$154.li1 VSS.$493.poly 152
Rext_4033 VSS.$156.li1 VSS.$160.li1 27.1058823529
Rext_4034 VSS.$156.li1 VSS.$330.met1 9.3
Rext_4035 VSS.$156.li1 VSS.$495.poly 152
Rext_4036 VSS.$158.li1 VSS.$162.li1 27.1058823529
Rext_4037 VSS.$158.li1 VSS.$331.met1 9.3
Rext_4038 VSS.$158.li1 VSS.$495.poly 152
Rext_4039 VSS.$16.li1 VSS.$18.li1 27.1058823529
Rext_4040 VSS.$16.li1 VSS.$237.met1 9.3
Rext_4041 VSS.$16.li1 VSS.P2.nsdm 185
Rext_4042 VSS.$160.li1 VSS.$164.li1 27.1058823529
Rext_4043 VSS.$160.li1 VSS.$332.met1 9.3
Rext_4044 VSS.$160.li1 VSS.$497.poly 152
Rext_4045 VSS.$162.li1 VSS.$166.li1 27.1058823529
Rext_4046 VSS.$162.li1 VSS.$333.met1 9.3
Rext_4047 VSS.$162.li1 VSS.$497.poly 152
Rext_4048 VSS.$164.li1 VSS.$168.li1 27.1058823529
Rext_4049 VSS.$164.li1 VSS.$334.met1 9.3
Rext_4050 VSS.$164.li1 VSS.$499.poly 152
Rext_4051 VSS.$166.li1 VSS.$170.li1 27.1058823529
Rext_4052 VSS.$166.li1 VSS.$335.met1 9.3
Rext_4053 VSS.$166.li1 VSS.$499.poly 152
Rext_4054 VSS.$168.li1 VSS.$172.li1 27.1058823529
Rext_4055 VSS.$168.li1 VSS.$336.met1 9.3
Rext_4056 VSS.$168.li1 VSS.$501.poly 152
Rext_4057 VSS.$170.li1 VSS.$174.li1 27.1058823529
Rext_4058 VSS.$170.li1 VSS.$337.met1 9.3
Rext_4059 VSS.$170.li1 VSS.$501.poly 152
Rext_4060 VSS.$172.li1 VSS.$176.li1 27.1058823529
Rext_4061 VSS.$172.li1 VSS.$338.met1 9.3
Rext_4062 VSS.$172.li1 VSS.$503.poly 152
Rext_4063 VSS.$174.li1 VSS.$178.li1 27.1058823529
Rext_4064 VSS.$174.li1 VSS.$339.met1 9.3
Rext_4065 VSS.$174.li1 VSS.$503.poly 152
Rext_4066 VSS.$176.li1 VSS.$180.li1 27.1058823529
Rext_4067 VSS.$176.li1 VSS.$340.met1 9.3
Rext_4068 VSS.$176.li1 VSS.$505.poly 152
Rext_4069 VSS.$178.li1 VSS.$182.li1 27.1058823529
Rext_4070 VSS.$178.li1 VSS.$341.met1 9.3
Rext_4071 VSS.$178.li1 VSS.$505.poly 152
Rext_4072 VSS.$18.li1 VSS.$20.li1 27.1058823529
Rext_4073 VSS.$18.li1 VSS.$238.met1 9.3
Rext_4074 VSS.$18.li1 VSS.P2.nsdm 185
Rext_4075 VSS.$180.li1 VSS.$184.li1 27.1058823529
Rext_4076 VSS.$180.li1 VSS.$342.met1 9.3
Rext_4077 VSS.$180.li1 VSS.$507.poly 152
Rext_4078 VSS.$182.li1 VSS.$186.li1 27.1058823529
Rext_4079 VSS.$182.li1 VSS.$343.met1 9.3
Rext_4080 VSS.$182.li1 VSS.$507.poly 152
Rext_4081 VSS.$184.li1 VSS.$188.li1 27.1058823529
Rext_4082 VSS.$184.li1 VSS.$344.met1 9.3
Rext_4083 VSS.$184.li1 VSS.$509.poly 152
Rext_4084 VSS.$186.li1 VSS.$190.li1 27.1058823529
Rext_4085 VSS.$186.li1 VSS.$345.met1 9.3
Rext_4086 VSS.$186.li1 VSS.$509.poly 152
Rext_4087 VSS.$188.li1 VSS.$192.li1 27.1058823529
Rext_4088 VSS.$188.li1 VSS.$346.met1 9.3
Rext_4089 VSS.$188.li1 VSS.$511.poly 152
Rext_4090 VSS.$190.li1 VSS.$194.li1 27.1058823529
Rext_4091 VSS.$190.li1 VSS.$347.met1 9.3
Rext_4092 VSS.$190.li1 VSS.$511.poly 152
Rext_4093 VSS.$192.li1 VSS.$196.li1 27.1058823529
Rext_4094 VSS.$192.li1 VSS.$348.met1 9.3
Rext_4095 VSS.$192.li1 VSS.$513.poly 152
Rext_4096 VSS.$194.li1 VSS.$198.li1 27.1058823529
Rext_4097 VSS.$194.li1 VSS.$349.met1 9.3
Rext_4098 VSS.$194.li1 VSS.$513.poly 152
Rext_4099 VSS.$196.li1 VSS.$200.li1 27.1058823529
Rext_4100 VSS.$196.li1 VSS.$350.met1 9.3
Rext_4101 VSS.$196.li1 VSS.$515.poly 152
Rext_4102 VSS.$198.li1 VSS.$202.li1 27.1058823529
Rext_4103 VSS.$198.li1 VSS.$351.met1 9.3
Rext_4104 VSS.$198.li1 VSS.$515.poly 152
Rext_4105 VSS.$2.li1 VSS.$212.met1 9.3
Rext_4106 VSS.$2.li1 VSS.P0.li1 15.3323827745
Rext_4107 VSS.$20.li1 VSS.$22.li1 27.1058823529
Rext_4108 VSS.$20.li1 VSS.$239.met1 9.3
Rext_4109 VSS.$20.li1 VSS.P2.nsdm 185
Rext_4110 VSS.$200.li1 VSS.$204.li1 27.1058823529
Rext_4111 VSS.$200.li1 VSS.$352.met1 9.3
Rext_4112 VSS.$200.li1 VSS.$517.poly 152
Rext_4113 VSS.$202.li1 VSS.$206.li1 27.1058823529
Rext_4114 VSS.$202.li1 VSS.$353.met1 9.3
Rext_4115 VSS.$202.li1 VSS.$517.poly 152
Rext_4116 VSS.$204.li1 VSS.$354.met1 9.3
Rext_4117 VSS.$204.li1 VSS.$519.poly 152
Rext_4118 VSS.$206.li1 VSS.$355.met1 9.3
Rext_4119 VSS.$206.li1 VSS.$519.poly 152
Rext_4120 VSS.$208.met1 VSS.$357.met2 4.5
Rext_4121 VSS.$209.met1 VSS.$358.met2 4.5
Rext_4122 VSS.$212.met1 VSS.$362.met2 4.5
Rext_4123 VSS.$213.met1 VSS.$3.li1 9.3
Rext_4124 VSS.$213.met1 VSS.$363.met2 4.5
Rext_4125 VSS.$214.met1 VSS.$364.met2 4.5
Rext_4126 VSS.$214.met1 VSS.$4.li1 9.3
Rext_4127 VSS.$218.met1 VSS.$367.met2 4.5
Rext_4128 VSS.$218.met1 VSS.$5.li1 9.3
Rext_4129 VSS.$22.li1 VSS.$24.li1 27.1058823529
Rext_4130 VSS.$22.li1 VSS.$240.met1 9.3
Rext_4131 VSS.$22.li1 VSS.P2.nsdm 185
Rext_4132 VSS.$220.met1 VSS.$368.met2 4.5
Rext_4133 VSS.$220.met1 VSS.$6.li1 9.3
Rext_4134 VSS.$222.met1 VSS.$370.met2 4.5
Rext_4135 VSS.$222.met1 VSS.$7.li1 9.3
Rext_4136 VSS.$223.met1 VSS.$371.met2 4.5
Rext_4137 VSS.$223.met1 VSS.$8.li1 9.3
Rext_4138 VSS.$224.met1 VSS.$372.met2 4.5
Rext_4139 VSS.$224.met1 VSS.$9.li1 9.3
Rext_4140 VSS.$228.met1 VSS.$373.met2 4.5
Rext_4141 VSS.$229.met1 VSS.$374.met2 4.5
Rext_4142 VSS.$230.met1 VSS.$375.met2 4.5
Rext_4143 VSS.$234.met1 VSS.$376.met2 4.5
Rext_4144 VSS.$236.met1 VSS.$258.met1 0.192934782609
Rext_4145 VSS.$237.met1 VSS.$238.met1 0.195652173913
Rext_4146 VSS.$237.met1 VSS.$258.met1 0.00271739130435
Rext_4147 VSS.$238.met1 VSS.$239.met1 0.195652173913
Rext_4148 VSS.$239.met1 VSS.$240.met1 0.195652173913
Rext_4149 VSS.$24.li1 VSS.$241.met1 9.3
Rext_4150 VSS.$24.li1 VSS.$26.li1 27.1058823529
Rext_4151 VSS.$24.li1 VSS.P2.nsdm 185
Rext_4152 VSS.$240.met1 VSS.$241.met1 0.195652173913
Rext_4153 VSS.$241.met1 VSS.$242.met1 0.195652173913
Rext_4154 VSS.$242.met1 VSS.$243.met1 0.195652173913
Rext_4155 VSS.$242.met1 VSS.$26.li1 9.3
Rext_4156 VSS.$243.met1 VSS.$244.met1 0.195652173913
Rext_4157 VSS.$243.met1 VSS.$28.li1 9.3
Rext_4158 VSS.$244.met1 VSS.$245.met1 0.195652173913
Rext_4159 VSS.$244.met1 VSS.$30.li1 9.3
Rext_4160 VSS.$245.met1 VSS.$246.met1 0.195652173913
Rext_4161 VSS.$245.met1 VSS.$32.li1 9.3
Rext_4162 VSS.$246.met1 VSS.$247.met1 0.195652173913
Rext_4163 VSS.$246.met1 VSS.$34.li1 9.3
Rext_4164 VSS.$247.met1 VSS.$248.met1 0.195652173913
Rext_4165 VSS.$247.met1 VSS.$36.li1 9.3
Rext_4166 VSS.$248.met1 VSS.$249.met1 0.195652173913
Rext_4167 VSS.$248.met1 VSS.$38.li1 9.3
Rext_4168 VSS.$249.met1 VSS.$250.met1 0.195652173913
Rext_4169 VSS.$249.met1 VSS.$40.li1 9.3
Rext_4170 VSS.$250.met1 VSS.$251.met1 0.195652173913
Rext_4171 VSS.$250.met1 VSS.$42.li1 9.3
Rext_4172 VSS.$251.met1 VSS.$252.met1 0.195652173913
Rext_4173 VSS.$251.met1 VSS.$44.li1 9.3
Rext_4174 VSS.$252.met1 VSS.$253.met1 0.195652173913
Rext_4175 VSS.$252.met1 VSS.$46.li1 9.3
Rext_4176 VSS.$253.met1 VSS.$254.met1 0.195652173913
Rext_4177 VSS.$253.met1 VSS.$48.li1 9.3
Rext_4178 VSS.$254.met1 VSS.$255.met1 0.195652173913
Rext_4179 VSS.$254.met1 VSS.$50.li1 9.3
Rext_4180 VSS.$255.met1 VSS.$256.met1 0.195652173913
Rext_4181 VSS.$255.met1 VSS.$52.li1 9.3
Rext_4182 VSS.$256.met1 VSS.$257.met1 0.195652173913
Rext_4183 VSS.$256.met1 VSS.$54.li1 9.3
Rext_4184 VSS.$257.met1 VSS.$56.li1 9.3
Rext_4185 VSS.$258.met1 VSS.$379.met2 4.5
Rext_4186 VSS.$259.met1 VSS.$383.met2 4.5
Rext_4187 VSS.$259.met1 VSS.$58.li1 9.3
Rext_4188 VSS.$26.li1 VSS.$28.li1 27.1058823529
Rext_4189 VSS.$26.li1 VSS.P2.nsdm 185
Rext_4190 VSS.$261.met1 VSS.$384.met2 4.5
Rext_4191 VSS.$261.met1 VSS.$59.li1 9.3
Rext_4192 VSS.$263.met1 VSS.$385.met2 4.5
Rext_4193 VSS.$263.met1 VSS.$60.li1 9.3
Rext_4194 VSS.$264.met1 VSS.$386.met2 4.5
Rext_4195 VSS.$264.met1 VSS.$61.li1 9.3
Rext_4196 VSS.$267.met1 VSS.$390.met2 4.5
Rext_4197 VSS.$267.met1 VSS.$62.li1 9.3
Rext_4198 VSS.$269.met1 VSS.$274.met1 0.192934782609
Rext_4199 VSS.$269.met1 VSS.$275.met1 0.00271739130435
Rext_4200 VSS.$269.met1 VSS.$393.met2 4.5
Rext_4201 VSS.$270.met1 VSS.$394.met2 4.5
Rext_4202 VSS.$270.met1 VSS.$63.li1 9.3
Rext_4203 VSS.$271.met1 VSS.$395.met2 4.5
Rext_4204 VSS.$271.met1 VSS.$64.li1 9.3
Rext_4205 VSS.$274.met1 VSS.$65.li1 9.3
Rext_4206 VSS.$275.met1 VSS.$276.met1 0.195652173913
Rext_4207 VSS.$275.met1 VSS.$67.li1 9.3
Rext_4208 VSS.$276.met1 VSS.$277.met1 0.195652173913
Rext_4209 VSS.$276.met1 VSS.$69.li1 9.3
Rext_4210 VSS.$277.met1 VSS.$278.met1 0.195652173913
Rext_4211 VSS.$277.met1 VSS.$71.li1 9.3
Rext_4212 VSS.$278.met1 VSS.$279.met1 0.195652173913
Rext_4213 VSS.$278.met1 VSS.$73.li1 9.3
Rext_4214 VSS.$279.met1 VSS.$280.met1 0.195652173913
Rext_4215 VSS.$279.met1 VSS.$75.li1 9.3
Rext_4216 VSS.$28.li1 VSS.$30.li1 27.1058823529
Rext_4217 VSS.$28.li1 VSS.P2.nsdm 185
Rext_4218 VSS.$280.met1 VSS.$281.met1 0.195652173913
Rext_4219 VSS.$280.met1 VSS.$77.li1 9.3
Rext_4220 VSS.$281.met1 VSS.$282.met1 0.195652173913
Rext_4221 VSS.$281.met1 VSS.$79.li1 9.3
Rext_4222 VSS.$282.met1 VSS.$283.met1 0.195652173913
Rext_4223 VSS.$282.met1 VSS.$81.li1 9.3
Rext_4224 VSS.$283.met1 VSS.$284.met1 0.195652173913
Rext_4225 VSS.$283.met1 VSS.$83.li1 9.3
Rext_4226 VSS.$284.met1 VSS.$285.met1 0.195652173913
Rext_4227 VSS.$284.met1 VSS.$85.li1 9.3
Rext_4228 VSS.$285.met1 VSS.$286.met1 0.195652173913
Rext_4229 VSS.$285.met1 VSS.$87.li1 9.3
Rext_4230 VSS.$286.met1 VSS.$287.met1 0.195652173913
Rext_4231 VSS.$286.met1 VSS.$89.li1 9.3
Rext_4232 VSS.$287.met1 VSS.$288.met1 0.195652173913
Rext_4233 VSS.$287.met1 VSS.$91.li1 9.3
Rext_4234 VSS.$288.met1 VSS.$289.met1 0.195652173913
Rext_4235 VSS.$288.met1 VSS.$93.li1 9.3
Rext_4236 VSS.$289.met1 VSS.$290.met1 0.195652173913
Rext_4237 VSS.$289.met1 VSS.$95.li1 9.3
Rext_4238 VSS.$290.met1 VSS.$291.met1 0.195652173913
Rext_4239 VSS.$290.met1 VSS.$97.li1 9.3
Rext_4240 VSS.$291.met1 VSS.$292.met1 0.195652173913
Rext_4241 VSS.$292.met1 VSS.$293.met1 0.195652173913
Rext_4242 VSS.$293.met1 VSS.$294.met1 0.195652173913
Rext_4243 VSS.$294.met1 VSS.$295.met1 0.195652173913
Rext_4244 VSS.$296.met1 VSS.$396.met2 4.5
Rext_4245 VSS.$298.met1 VSS.$398.met2 4.5
Rext_4246 VSS.$3.li1 VSS.P10.li1 15.3323827745
Rext_4247 VSS.$30.li1 VSS.$32.li1 27.1058823529
Rext_4248 VSS.$30.li1 VSS.P2.nsdm 185
Rext_4249 VSS.$300.met1 VSS.$301.met1 0.138586956522
Rext_4250 VSS.$300.met1 VSS.$302.met1 0.0570652173913
Rext_4251 VSS.$300.met1 VSS.$400.met2 4.5
Rext_4252 VSS.$303.met1 VSS.$401.met2 4.5
Rext_4253 VSS.$305.met1 VSS.$404.met2 4.5
Rext_4254 VSS.$307.met1 VSS.$308.met1 0.0567154373501
Rext_4255 VSS.$308.met1 VSS.$406.met2 4.5
Rext_4256 VSS.$309.met1 VSS.$409.met2 4.5
Rext_4257 VSS.$311.met1 VSS.$313.met1 0.195652173913
Rext_4258 VSS.$312.met1 VSS.$314.met1 0.195652173913
Rext_4259 VSS.$313.met1 VSS.$315.met1 0.10597826087
Rext_4260 VSS.$314.met1 VSS.$317.met1 0.195652173913
Rext_4261 VSS.$315.met1 VSS.$316.met1 0.0896739130435
Rext_4262 VSS.$315.met1 VSS.$411.met2 4.5
Rext_4263 VSS.$316.met1 VSS.$318.met1 0.195652173913
Rext_4264 VSS.$317.met1 VSS.$319.met1 0.195652173913
Rext_4265 VSS.$318.met1 VSS.$320.met1 0.195652173913
Rext_4266 VSS.$319.met1 VSS.$321.met1 0.195652173913
Rext_4267 VSS.$32.li1 VSS.$34.li1 27.1058823529
Rext_4268 VSS.$32.li1 VSS.P2.nsdm 185
Rext_4269 VSS.$320.met1 VSS.$322.met1 0.195652173913
Rext_4270 VSS.$321.met1 VSS.$323.met1 0.195652173913
Rext_4271 VSS.$322.met1 VSS.$324.met1 0.195652173913
Rext_4272 VSS.$323.met1 VSS.$325.met1 0.195652173913
Rext_4273 VSS.$324.met1 VSS.$326.met1 0.195652173913
Rext_4274 VSS.$325.met1 VSS.$327.met1 0.195652173913
Rext_4275 VSS.$326.met1 VSS.$328.met1 0.195652173913
Rext_4276 VSS.$327.met1 VSS.$329.met1 0.195652173913
Rext_4277 VSS.$328.met1 VSS.$330.met1 0.195652173913
Rext_4278 VSS.$329.met1 VSS.$331.met1 0.195652173913
Rext_4279 VSS.$330.met1 VSS.$332.met1 0.195652173913
Rext_4280 VSS.$331.met1 VSS.$333.met1 0.195652173913
Rext_4281 VSS.$332.met1 VSS.$334.met1 0.195652173913
Rext_4282 VSS.$333.met1 VSS.$335.met1 0.195652173913
Rext_4283 VSS.$334.met1 VSS.$336.met1 0.195652173913
Rext_4284 VSS.$335.met1 VSS.$337.met1 0.195652173913
Rext_4285 VSS.$336.met1 VSS.$338.met1 0.195652173913
Rext_4286 VSS.$337.met1 VSS.$339.met1 0.195652173913
Rext_4287 VSS.$338.met1 VSS.$340.met1 0.195652173913
Rext_4288 VSS.$339.met1 VSS.$341.met1 0.195652173913
Rext_4289 VSS.$34.li1 VSS.$36.li1 27.1058823529
Rext_4290 VSS.$34.li1 VSS.P2.nsdm 185
Rext_4291 VSS.$340.met1 VSS.$342.met1 0.195652173913
Rext_4292 VSS.$341.met1 VSS.$343.met1 0.195652173913
Rext_4293 VSS.$342.met1 VSS.$344.met1 0.195652173913
Rext_4294 VSS.$343.met1 VSS.$345.met1 0.195652173913
Rext_4295 VSS.$344.met1 VSS.$346.met1 0.195652173913
Rext_4296 VSS.$345.met1 VSS.$347.met1 0.195652173913
Rext_4297 VSS.$346.met1 VSS.$348.met1 0.195652173913
Rext_4298 VSS.$347.met1 VSS.$349.met1 0.195652173913
Rext_4299 VSS.$348.met1 VSS.$350.met1 0.195652173913
Rext_4300 VSS.$349.met1 VSS.$351.met1 0.195652173913
Rext_4301 VSS.$350.met1 VSS.$352.met1 0.195652173913
Rext_4302 VSS.$351.met1 VSS.$353.met1 0.195652173913
Rext_4303 VSS.$352.met1 VSS.$354.met1 0.195652173913
Rext_4304 VSS.$353.met1 VSS.$355.met1 0.195652173913
Rext_4305 VSS.$356.met2 VSS.$357.met2 0.357613893922
Rext_4306 VSS.$356.met2 VSS.$412.met3 3.41
Rext_4307 VSS.$358.met2 VSS.$359.met2 1.28090068906
Rext_4308 VSS.$359.met2 VSS.$361.met2 0.97402821011
Rext_4309 VSS.$359.met2 VSS.$363.met2 1.52558266666
Rext_4310 VSS.$36.li1 VSS.$38.li1 27.1058823529
Rext_4311 VSS.$36.li1 VSS.P2.nsdm 185
Rext_4312 VSS.$360.met2 VSS.$362.met2 0.0876495151583
Rext_4313 VSS.$360.met2 VSS.$413.met3 3.41
Rext_4314 VSS.$361.met2 VSS.$364.met2 0.0506139843386
Rext_4315 VSS.$361.met2 VSS.$414.met3 3.41
Rext_4316 VSS.$362.met2 VSS.$365.met2 1.35907533139
Rext_4317 VSS.$363.met2 VSS.$365.met2 2.14417159851
Rext_4318 VSS.$365.met2 VSS.$367.met2 0.0703877445196
Rext_4319 VSS.$366.met2 VSS.$368.met2 0.33891179514
Rext_4320 VSS.$366.met2 VSS.$415.met3 3.41
Rext_4321 VSS.$369.met2 VSS.$372.met2 0.0876931199368
Rext_4322 VSS.$369.met2 VSS.$375.met2 1.27089516666
Rext_4323 VSS.$369.met2 VSS.$416.met3 3.41
Rext_4324 VSS.$370.met2 VSS.$373.met2 0.409176393922
Rext_4325 VSS.$370.met2 VSS.$374.met2 1.1921875
Rext_4326 VSS.$371.met2 VSS.$374.met2 1.3078125
Rext_4327 VSS.$371.met2 VSS.$375.met2 1.1921875
Rext_4328 VSS.$376.met2 VSS.$377.met2 0.170299704301
Rext_4329 VSS.$377.met2 VSS.$378.met2 2.86630127181
Rext_4330 VSS.$377.met2 VSS.$417.met3 3.41
Rext_4331 VSS.$378.met2 VSS.$379.met2 0.0114900978018
Rext_4332 VSS.$378.met2 VSS.$380.met2 0.657807737327
Rext_4333 VSS.$38.li1 VSS.$40.li1 27.1058823529
Rext_4334 VSS.$38.li1 VSS.P2.nsdm 185
Rext_4335 VSS.$380.met2 VSS.$383.met2 8.03522772127
Rext_4336 VSS.$380.met2 VSS.$389.met2 2.13931152032
Rext_4337 VSS.$381.met2 VSS.$382.met2 1.29074705203
Rext_4338 VSS.$381.met2 VSS.$384.met2 0.0227440785253
Rext_4339 VSS.$381.met2 VSS.$418.met3 3.41
Rext_4340 VSS.$382.met2 VSS.$383.met2 0.0708545388857
Rext_4341 VSS.$382.met2 VSS.$419.met3 3.41
Rext_4342 VSS.$385.met2 VSS.$387.met2 2.84340068906
Rext_4343 VSS.$386.met2 VSS.$387.met2 0.357613893922
Rext_4344 VSS.$387.met2 VSS.$388.met2 2.75
Rext_4345 VSS.$387.met2 VSS.$391.met2 0.935240963855
Rext_4346 VSS.$388.met2 VSS.$420.met3 3.41
Rext_4347 VSS.$389.met2 VSS.$390.met2 0.0809554954492
Rext_4348 VSS.$389.met2 VSS.$392.met2 1.69438101829
Rext_4349 VSS.$391.met2 VSS.$394.met2 1.59487241739
Rext_4350 VSS.$391.met2 VSS.$395.met2 0.0496987951807
Rext_4351 VSS.$391.met2 VSS.$421.met3 3.41
Rext_4352 VSS.$392.met2 VSS.$393.met2 0.0316101523455
Rext_4353 VSS.$392.met2 VSS.$422.met3 3.41
Rext_4354 VSS.$397.met2 VSS.$398.met2 0.00892857142857
Rext_4355 VSS.$397.met2 VSS.$423.met3 3.41
Rext_4356 VSS.$4.li1 VSS.P6.li1 15.3323827745
Rext_4357 VSS.$40.li1 VSS.$42.li1 27.1058823529
Rext_4358 VSS.$40.li1 VSS.P2.nsdm 185
Rext_4359 VSS.$401.met2 VSS.$403.met2 0.0901441682773
Rext_4360 VSS.$402.met2 VSS.$404.met2 0.0496987951807
Rext_4361 VSS.$402.met2 VSS.$425.met3 3.41
Rext_4362 VSS.$403.met2 VSS.$405.met2 0.646636086132
Rext_4363 VSS.$403.met2 VSS.$426.met3 3.41
Rext_4364 VSS.$405.met2 VSS.$406.met2 0.0441979961929
Rext_4365 VSS.$405.met2 VSS.$407.met2 0.70190022058
Rext_4366 VSS.$407.met2 VSS.$427.met3 3.41
Rext_4367 VSS.$408.met2 VSS.$409.met2 0.811141865786
Rext_4368 VSS.$408.met2 VSS.$428.met3 3.41
Rext_4369 VSS.$410.met2 VSS.$411.met2 5.75096683329
Rext_4370 VSS.$410.met2 VSS.$429.met3 3.41
Rext_4371 VSS.$412.met3 VSS.$413.met3 0.31725
Rext_4372 VSS.$414.met3 VSS.$416.met3 0.52875
Rext_4373 VSS.$415.met3 VSS.$417.met3 0.846
Rext_4374 VSS.$416.met3 VSS.$419.met3 0.846
Rext_4375 VSS.$418.met3 VSS.$420.met3 0.2115
Rext_4376 VSS.$42.li1 VSS.$44.li1 27.1058823529
Rext_4377 VSS.$42.li1 VSS.P2.nsdm 185
Rext_4378 VSS.$421.met3 VSS.$423.met3 0.6345
Rext_4379 VSS.$422.met3 VSS.$424.met3 0.74025
Rext_4380 VSS.$423.met3 VSS.$425.met3 0.423
Rext_4381 VSS.$424.met3 VSS.$426.met3 0.31725
Rext_4382 VSS.$427.met3 VSS.$428.met3 0.2115
Rext_4383 VSS.$428.met3 VSS.$429.met3 1.16325
Rext_4384 VSS.$44.li1 VSS.$46.li1 27.1058823529
Rext_4385 VSS.$44.li1 VSS.P2.nsdm 185
Rext_4386 VSS.$46.li1 VSS.$48.li1 27.1058823529
Rext_4387 VSS.$46.li1 VSS.P2.nsdm 185
Rext_4388 VSS.$477.poly VSS.$479.poly 11.7243243243
Rext_4389 VSS.$479.poly VSS.$481.poly 11.7243243243
Rext_4390 VSS.$48.li1 VSS.$50.li1 27.1058823529
Rext_4391 VSS.$48.li1 VSS.P2.nsdm 185
Rext_4392 VSS.$481.poly VSS.$483.poly 11.7243243243
Rext_4393 VSS.$483.poly VSS.$485.poly 11.7243243243
Rext_4394 VSS.$485.poly VSS.$487.poly 11.7243243243
Rext_4395 VSS.$487.poly VSS.$489.poly 11.7243243243
Rext_4396 VSS.$489.poly VSS.$491.poly 11.7243243243
Rext_4397 VSS.$491.poly VSS.$493.poly 11.7243243243
Rext_4398 VSS.$493.poly VSS.$495.poly 11.7243243243
Rext_4399 VSS.$495.poly VSS.$497.poly 11.7243243243
Rext_4400 VSS.$497.poly VSS.P0.poly 5.86216216216
Rext_4401 VSS.$499.poly VSS.$501.poly 11.7243243243
Rext_4402 VSS.$499.poly VSS.P0.poly 5.86216216216
Rext_4403 VSS.$5.li1 VSS.P10.li1 37.3701998049
Rext_4404 VSS.$50.li1 VSS.$52.li1 27.1058823529
Rext_4405 VSS.$50.li1 VSS.P2.nsdm 185
Rext_4406 VSS.$501.poly VSS.$503.poly 11.7243243243
Rext_4407 VSS.$503.poly VSS.$505.poly 11.7243243243
Rext_4408 VSS.$505.poly VSS.$507.poly 11.7243243243
Rext_4409 VSS.$507.poly VSS.$509.poly 11.7243243243
Rext_4410 VSS.$509.poly VSS.$511.poly 11.7243243243
Rext_4411 VSS.$511.poly VSS.$513.poly 11.7243243243
Rext_4412 VSS.$513.poly VSS.$515.poly 11.7243243243
Rext_4413 VSS.$515.poly VSS.$517.poly 11.7243243243
Rext_4414 VSS.$517.poly VSS.$519.poly 11.7243243243
Rext_4415 VSS.$52.li1 VSS.$54.li1 27.1058823529
Rext_4416 VSS.$52.li1 VSS.P2.nsdm 185
Rext_4417 VSS.$54.li1 VSS.$56.li1 27.1058823529
Rext_4418 VSS.$54.li1 VSS.P2.nsdm 185
Rext_4419 VSS.$56.li1 VSS.P2.nsdm 185
Rext_4420 VSS.$58.li1 VSS.P2.li1 37.4111066681
Rext_4421 VSS.$59.li1 VSS.P2.li1 34.1691056881
Rext_4422 VSS.$60.li1 VSS.P12.li1 34.1691056881
Rext_4423 VSS.$61.li1 VSS.P8.li1 34.1691056881
Rext_4424 VSS.$63.li1 VSS.P12.li1 15.3323827745
Rext_4425 VSS.$64.li1 VSS.P8.li1 37.3961292261
Rext_4426 VSS.$65.li1 VSS.$67.li1 27.1058823529
Rext_4427 VSS.$65.li1 VSS.P3.nsdm 185
Rext_4428 VSS.$67.li1 VSS.$69.li1 27.1058823529
Rext_4429 VSS.$67.li1 VSS.P3.nsdm 185
Rext_4430 VSS.$69.li1 VSS.$71.li1 27.1058823529
Rext_4431 VSS.$69.li1 VSS.P3.nsdm 185
Rext_4432 VSS.$7.li1 VSS.P14.li1 37.4111066681
Rext_4433 VSS.$71.li1 VSS.$73.li1 27.1058823529
Rext_4434 VSS.$71.li1 VSS.P3.nsdm 185
Rext_4435 VSS.$73.li1 VSS.$75.li1 27.1058823529
Rext_4436 VSS.$73.li1 VSS.P3.nsdm 185
Rext_4437 VSS.$75.li1 VSS.$77.li1 27.1058823529
Rext_4438 VSS.$75.li1 VSS.P3.nsdm 185
Rext_4439 VSS.$77.li1 VSS.$79.li1 27.1058823529
Rext_4440 VSS.$77.li1 VSS.P3.nsdm 185
Rext_4441 VSS.$79.li1 VSS.$81.li1 27.1058823529
Rext_4442 VSS.$79.li1 VSS.P3.nsdm 185
Rext_4443 VSS.$8.li1 VSS.P18.li1 37.4111066681
Rext_4444 VSS.$81.li1 VSS.$83.li1 27.1058823529
Rext_4445 VSS.$81.li1 VSS.P3.nsdm 185
Rext_4446 VSS.$83.li1 VSS.$85.li1 27.1058823529
Rext_4447 VSS.$83.li1 VSS.P3.nsdm 185
Rext_4448 VSS.$85.li1 VSS.$87.li1 27.1058823529
Rext_4449 VSS.$85.li1 VSS.P3.nsdm 185
Rext_4450 VSS.$87.li1 VSS.$89.li1 27.1058823529
Rext_4451 VSS.$87.li1 VSS.P3.nsdm 185
Rext_4452 VSS.$89.li1 VSS.$91.li1 27.1058823529
Rext_4453 VSS.$89.li1 VSS.P3.nsdm 185
Rext_4454 VSS.$9.li1 VSS.P4.li1 37.4111066681
Rext_4455 VSS.$91.li1 VSS.$93.li1 27.1058823529
Rext_4456 VSS.$91.li1 VSS.P3.nsdm 185
Rext_4457 VSS.$93.li1 VSS.$95.li1 27.1058823529
Rext_4458 VSS.$93.li1 VSS.P3.nsdm 185
Rext_4459 VSS.$95.li1 VSS.$97.li1 27.1058823529
Rext_4460 VSS.$95.li1 VSS.P3.nsdm 185
Rext_4461 VSS.$97.li1 VSS.P3.nsdm 185
.ENDS BANDGAP
