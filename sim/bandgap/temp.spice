* 2. Temperature sweep, -40 to 125 C: VREF drift and box-method TC
.include bench.spice
.control
save v(vref)
dc temp -40 125 1
meas dc vmax max v(vref)
meas dc vmin min v(vref)
meas dc v27 find v(vref) at=27
let tc_ppm = (vmax - vmin) / (v27 * 165) * 1e6
print tc_ppm
wrdata out/temp.dat v(vref)
.endc
.end
